*  Generated for: HSPICE
*  Design library name: ram8t_custom
*  Design cell name: ram8t_cell_test
*  Design view name: config

.option PARHIER = LOCAL
.include 'snm_include.sp'
.option PORT_VOLTAGE_SCALE_TO_2X = 1

.option ARTIST=2 PSF=2
.temp 25
.include 'reference_models.inc'
.include 'ram8t_cell_test_ic_lay.sp'
*Custom Compiler Version N-2017.12-SP1-2
*Sun Nov 22 22:36:34 2026

.GLOBAL 0 gnd! vdd!
********************************************************************************
* Library          : ram8t_custom
* Cell             : ram8t_cell
* View             : starrc
* View Search List : schematic hspice symbol
* View Stop List   : symbol
********************************************************************************
.subckt ram8t_cell rbl rwl wbl wblb wwl
r216 170:qb 171:qb  r=89.1001
r215 169:qb 178:qb  r=0.135333
r214 168:qb 176:qb  r=0.098
r213 168:qb 175:qb  r=0.098
r212 167:qb 169:qb  r=0.401333
r211 167:qb 168:qb  r=2
r210 165:qb 167:qb  r=0.788666
r209 165:qb 166:qb  r=0.098
r208 163:qb 175:qb  r=1.54
r207 163:qb 164:qb  r=0.119
r206 162:qb 179:qb  r=0.119
r205 162:qb 176:qb  r=0.42
r204 160:qb 171:qb  r=4.3125
r203 160:qb 161:qb  r=4.3125
r202 159:qb 181:qb  r=0.05005
r201 159:qb 177:qb  r=0.05005
r200 159:qb 169:qb  r=2
r199 159:qb 160:qb  r=18
r198 157:qb 172:qb  r=5.44737
r197 157:qb 158:qb  r=5.44737
r196 156:qb 180:qb  r=0.05005
r195 156:qb 174:qb  r=0.05005
r194 156:qb 165:qb  r=2
r193 156:qb 157:qb  r=18
r192 154:qb 163:qb  r=18
r191 154:qb mpd2|drn  r=7.5
r190 mpg2|drn 154:qb  r=7.5
r189 153:qb qb  r=11.7
r188 mpd1|gate 170:qb  r=9.00001
r187 mpd1|gate 153:qb  r=9.00001
r186 152:qb 161:qb  r=17.1
r185 151:qb 173:qb  r=11.7
r184 mpu1|gate 152:qb  r=9.00001
r183 mpu1|gate 151:qb  r=9.00001
r182 150:qb 155:qb  r=11.7
r181 149:qb 172:qb  r=89.1001
r180 mra1|gate 150:qb  r=9.00001
r179 mra1|gate 149:qb  r=9.00001
r178 148:qb mpu2|drn  r=13.2
r177 147:qb 162:qb  r=18
r176 147:qb mpu2|drn  r=7.5
r175 147:qb 148:qb  r=5.7
r174 139:q 140:q  r=35.1
r173 138:q 143:q  r=0.098
r172 138:q 142:q  r=0.098
r171 137:q 145:q  r=0.098
r170 137:q 138:q  r=2
r169 134:q 137:q  r=0.443333
r168 134:q 136:q  r=0.098
r167 132:q 142:q  r=0.7
r166 132:q 133:q  r=0.119
r165 131:q 146:q  r=0.119
r164 131:q 143:q  r=1.26
r163 129:q 140:q  r=5.3077
r162 129:q 130:q  r=5.3077
r161 128:q 144:q  r=0.130667
r160 128:q 135:q  r=0.130667
r159 128:q 134:q  r=2
r158 128:q 129:q  r=18
r157 127:q 132:q  r=18
r156 127:q mpg1|src  r=7.5
r155 mpd1|drn 127:q  r=7.5
r154 126:q q  r=11.7
r153 mpd2|gate 139:q  r=9.00001
r152 mpd2|gate 126:q  r=9.00001
r151 125:q 130:q  r=71.1001
r150 124:q 141:q  r=11.7
r149 mpu2|gate 125:q  r=9.00001
r148 mpu2|gate 124:q  r=9.00001
r147 123:q 131:q  r=18
r146 123:q mpu1|drn  r=7.5
r145 122:q mpu1|drn  r=13.2
r144 122:q 123:q  r=5.7
r143 120:ln_n_63 121:ln_n_63  r=10.8947
r142 119:ln_n_63 ln_n_63  r=53.5501
r141 117:ln_n_63 118:ln_n_63  r=53.5501
r140 117:ln_n_63 119:ln_n_63  r=104
r139 117:ln_n_63 120:ln_n_63  r=29
r138 mra2|bulk mpg1|bulk  r=0.001
r137 mra2|bulk mpd2|bulk  r=0.001
r136 mra2|bulk mpd1|bulk  r=0.001
r135 mra2|bulk mra1|bulk  r=0.001
r134 ln_n_38 mra2|bulk  r=0.001
r133 ln_n_38 mpg2|bulk  r=0.001
r132 116:ln_n_65 ln_n_65  r=41.4
r131 114:ln_n_65 116:ln_n_65  r=57.5527
r130 114:ln_n_65 115:ln_n_65  r=5.37288
r129 111:ln_n_61 ln_n_61  r=123.3
r128 111:ln_n_61 112:ln_n_61  r=51.3001
r127 111:ln_n_61 113:ln_n_61  r=7.43479
r126 109:net5 110:net5  r=0.0665
r125 109:net5 net5  r=0.0735
r124 108:net5 109:net5  r=18
r123 108:net5 mra1|drn  r=7.5
r122 mra2|src 108:net5  r=7.5
r121 105:wblb 107:wblb  r=2.506
r120 105:wblb 106:wblb  r=0.119
r119 wblb 107:wblb  r=0.105
r118 wblb 104:wblb  r=0.105
r117 102:wblb 105:wblb  r=18
r116 102:wblb mpg2|src  r=7.5
r115 102:wblb 103:wblb  r=5.7
r114 99:rbl 101:rbl  r=2.506
r113 99:rbl 100:rbl  r=0.119
r112 rbl 101:rbl  r=0.105
r111 rbl 98:rbl  r=0.105
r110 96:rbl 99:rbl  r=18
r109 96:rbl mra2|drn  r=7.5
r108 96:rbl 97:rbl  r=5.7
r107 90:rwl 92:rwl  r=0.424666
r106 88:rwl 95:rwl  r=0.130667
r105 88:rwl 91:rwl  r=0.130667
r104 88:rwl 90:rwl  r=2
r103 rwl 90:rwl  r=2.33333
r102 87:rwl 94:rwl  r=11.7
r101 mra2|gate 87:rwl  r=9.00001
r100 86:rwl 93:rwl  r=11.7
r99 86:rwl mra2|gate  r=9.00001
r98 85:rwl 93:rwl  r=57.5527
r97 84:rwl 89:rwl  r=3.7174
r96 84:rwl 88:rwl  r=18
r95 84:rwl 85:rwl  r=1.07197
r94 76:gnd! 79:gnd!  r=0.098
r93 76:gnd! 77:gnd!  r=0.098
r92 75:gnd! 78:gnd!  r=0.723333
r91 75:gnd! 76:gnd!  r=2
r90 73:gnd! 80:gnd!  r=0.098
r89 73:gnd! 74:gnd!  r=0.098
r88 72:gnd! 75:gnd!  r=0.68
r87 72:gnd! 73:gnd!  r=2
r86 71:gnd! 83:gnd!  r=0.119
r85 71:gnd! 79:gnd!  r=0.448
r84 70:gnd! 82:gnd!  r=0.119
r83 70:gnd! 80:gnd!  r=0.448
r82 69:gnd! 81:gnd!  r=0.266667
r81 gnd! 72:gnd!  r=0.15
r80 68:gnd! 69:gnd!  r=0.1
r79 68:gnd! gnd!  r=0.1
r78 67:gnd! 71:gnd!  r=18
r77 67:gnd! mpd1|src  r=7.5
r76 mpd2|src 67:gnd!  r=7.5
r75 66:gnd! 70:gnd!  r=18
r74 66:gnd! mra1|src  r=7.5
r73 65:gnd! 66:gnd!  r=5.7
r72 57:wwl 64:wwl  r=0.119
r71 57:wwl 63:wwl  r=0.791
r70 55:wwl 63:wwl  r=0.098
r69 55:wwl 58:wwl  r=0.098
r68 wwl 59:wwl  r=2.688
r67 wwl 55:wwl  r=2
r66 54:wwl 62:wwl  r=11.7
r65 mpg1|gate 56:wwl  r=9.00001
r64 mpg1|gate 54:wwl  r=9.00001
r63 53:wwl 61:wwl  r=11.7
r62 mpg2|gate 60:wwl  r=9.00001
r61 mpg2|gate 53:wwl  r=9.00001
r60 51:wwl 57:wwl  r=18
r59 51:wwl 52:wwl  r=5.44737
r58 50:wwl 51:wwl  r=5.44737
r57 49:wwl 56:wwl  r=23.85
r56 49:wwl 52:wwl  r=29
r55 48:wwl 60:wwl  r=23.85
r54 48:wwl 49:wwl  r=104
r53 45:wbl 47:wbl  r=2.506
r52 45:wbl 46:wbl  r=0.119
r51 wbl 47:wbl  r=0.105
r50 wbl 44:wbl  r=0.105
r49 43:wbl 45:wbl  r=18
r48 43:wbl mpg1|drn  r=7.5
r47 42:wbl 43:wbl  r=5.7
r46 36:vdd! 40:vdd!  r=0.098
r45 36:vdd! 37:vdd!  r=0.098
r44 35:vdd! 38:vdd!  r=0.723333
r43 35:vdd! 36:vdd!  r=2
r42 34:vdd! 41:vdd!  r=0.119
r41 34:vdd! 40:vdd!  r=0.168
r40 33:vdd! 39:vdd!  r=0.26
r39 vdd! 35:vdd!  r=0.836666
r38 32:vdd! 33:vdd!  r=0.1
r37 32:vdd! vdd!  r=0.1
r36 31:vdd! 34:vdd!  r=18
r35 31:vdd! mpu1|src  r=7.5
r34 mpu2|src mpu1|src  r=15
r33 mpu2|src 31:vdd!  r=7.5
r32 ln_n_40 mpu2|bulk  r=0.001
r31 ln_n_40 mpu1|bulk  r=0.001
r30 29:ln_n_64 ln_n_64  r=10.8947
r29 29:ln_n_64 30:ln_n_64  r=118.8
r28 27:ln_n_62 28:ln_n_62  r=100.8
r27 26:ln_n_62 ln_n_62  r=64.8001
r26 26:ln_n_62 27:ln_n_62  r=10.6154
r25 25:ln_n_55 ln_n_55  r=0.21
r24 24:ln_n_55 25:ln_n_55  r=2.625
r23 23:ln_n_59 ln_n_59  r=0.1001
r22 22:ln_n_57 ln_n_57  r=0.567
r21 21:ln_n_57 22:ln_n_57  r=0.196
r20 20:ln_n_56 ln_n_56  r=0.21
r19 19:ln_n_56 20:ln_n_56  r=2.625
r18 17:ln_n_48 18:ln_n_48  r=1.659
r17 16:ln_n_48 ln_n_48  r=0.539
r16 16:ln_n_48 17:ln_n_48  r=0.196
r15 15:ln_n_49 ln_n_49  r=0.287
r14 14:ln_n_49 15:ln_n_49  r=0.196
r13 13:ln_n_53 ln_n_53  r=0.567
r12 12:ln_n_53 13:ln_n_53  r=0.196
r11 11:ln_n_60 ln_n_60  r=0.1001
r10 9:ln_n_47 10:ln_n_47  r=0.819
r9 8:ln_n_47 ln_n_47  r=1.379
r8 8:ln_n_47 9:ln_n_47  r=0.196
r7 7:ln_n_50 ln_n_50  r=0.21
r6 6:ln_n_50 7:ln_n_50  r=2.625
r5 5:ln_n_52 ln_n_52  r=0.91
r4 4:ln_n_52 5:ln_n_52  r=0.196
r3 3:ln_n_58 ln_n_58  r=0.14
r2 2:ln_n_54 ln_n_54  r=0.261333
r1 1:ln_n_51 ln_n_51  r=0.261333
cg449 181:qb 0  c=2.45415e-18
c448 181:qb 144:q  c=2.1131e-18
c447 181:qb 83:gnd!  c=7.31154e-20
c446 181:qb 28:ln_n_62  c=1.52234e-18
c445 181:qb 79:gnd!  c=3.21248e-20
c444 181:qb 27:ln_n_62  c=3.4278e-19
c443 181:qb mra2|bulk  c=6.71319e-19
c442 181:qb 146:q  c=3.21778e-18
c441 181:qb 113:ln_n_61  c=1.57924e-17
c440 181:qb 145:q  c=1.23943e-18
c439 181:qb 111:ln_n_61  c=6.2621e-18
c438 181:qb rwl  c=2.23778e-17
c437 181:qb 120:ln_n_63  c=7.61222e-20
cg436 180:qb 0  c=2.09884e-18
c435 180:qb 65:gnd!  c=3.53201e-19
c434 180:qb 82:gnd!  c=5.08947e-19
c433 180:qb 80:gnd!  c=1.8463e-21
c432 180:qb 107:wblb  c=9.70873e-19
c431 180:qb 30:ln_n_64  c=7.28183e-18
c430 180:qb 29:ln_n_64  c=1.53949e-17
c429 180:qb mra2|bulk  c=1.15854e-18
c428 180:qb rwl  c=2.38502e-17
c427 180:qb wwl  c=1.37968e-18
c426 180:qb 95:rwl  c=3.33313e-18
cg425 179:qb 0  c=1.08881e-17
c424 179:qb 107:wblb  c=1.33428e-17
c423 179:qb 29:ln_n_64  c=1.14611e-20
c422 179:qb 41:vdd!  c=6.90231e-18
c421 179:qb 28:ln_n_62  c=2.18148e-17
c420 179:qb 40:vdd!  c=1.46138e-18
c419 179:qb 125:q  c=1.79186e-18
c418 179:qb 112:ln_n_61  c=6.65085e-20
c417 179:qb mra2|bulk  c=9.6917e-20
c416 179:qb 146:q  c=6.57226e-19
c415 179:qb 32:vdd!  c=5.40486e-17
c414 179:qb mpu2|bulk  c=1.88792e-18
cg413 178:qb 0  c=1.73614e-17
c412 178:qb 119:ln_n_63  c=9.32816e-20
c411 178:qb 107:wblb  c=9.40043e-17
c410 178:qb 144:q  c=3.57297e-19
c409 178:qb 41:vdd!  c=3.15703e-18
c408 178:qb 40:vdd!  c=2.50697e-19
c407 178:qb mra2|bulk  c=1.04103e-17
c406 178:qb 146:q  c=1.11547e-17
c405 178:qb 145:q  c=3.61246e-18
c404 178:qb 32:vdd!  c=3.74034e-17
c403 178:qb rwl  c=1.0078e-16
c402 178:qb mpu2|bulk  c=3.88438e-18
c401 178:qb wwl  c=3.5284e-18
c400 178:qb 95:rwl  c=3.68719e-18
c399 177:qb 107:wblb  c=9.95195e-21
c398 177:qb 144:q  c=9.70333e-20
c397 177:qb 41:vdd!  c=9.81458e-18
c396 177:qb 28:ln_n_62  c=1.00134e-17
c395 177:qb 40:vdd!  c=2.19221e-19
c394 177:qb 27:ln_n_62  c=4.34805e-20
c393 177:qb 112:ln_n_61  c=6.72305e-18
c392 177:qb mra2|bulk  c=4.38869e-19
c391 177:qb 146:q  c=2.07886e-17
c390 177:qb 113:ln_n_61  c=4.70504e-17
c389 177:qb 145:q  c=5.51253e-20
c388 177:qb 32:vdd!  c=1.39524e-18
c387 177:qb rwl  c=1.1647e-18
c386 177:qb mpu2|bulk  c=7.11505e-19
c385 176:qb 60:wwl  c=3.22556e-19
c384 176:qb 119:ln_n_63  c=3.93382e-19
c383 176:qb 107:wblb  c=7.61319e-18
c382 176:qb 144:q  c=1.79816e-19
c381 176:qb 29:ln_n_64  c=2.37089e-19
c380 176:qb 28:ln_n_62  c=1.93171e-17
c379 176:qb 112:ln_n_61  c=1.45078e-19
c378 176:qb mra2|bulk  c=3.73476e-19
c377 176:qb 146:q  c=4.34902e-20
c376 176:qb 113:ln_n_61  c=4.28158e-19
c375 176:qb 145:q  c=4.58554e-19
c374 176:qb 32:vdd!  c=5.83451e-19
c373 176:qb 111:ln_n_61  c=1.45078e-19
c372 176:qb rwl  c=7.85861e-18
c371 176:qb mpu2|bulk  c=8.04514e-20
c370 176:qb wwl  c=1.22759e-19
cg369 175:qb 0  c=6.81076e-18
c368 175:qb 60:wwl  c=5.17293e-19
c367 175:qb 139:q  c=3.64732e-18
c366 175:qb 82:gnd!  c=8.62198e-19
c365 175:qb 119:ln_n_63  c=1.37521e-17
c364 175:qb 107:wblb  c=3.1388e-17
c363 175:qb 30:ln_n_64  c=1.01395e-18
c362 175:qb 144:q  c=2.91224e-17
c361 175:qb 29:ln_n_64  c=1.14611e-20
c360 175:qb 83:gnd!  c=1.06698e-17
c359 175:qb 28:ln_n_62  c=1.89392e-17
c358 175:qb 26:ln_n_62  c=3.18446e-17
c357 175:qb 27:ln_n_62  c=1.02803e-17
c356 175:qb mra2|bulk  c=7.34566e-19
c355 175:qb 146:q  c=4.2217e-19
c354 175:qb 145:q  c=8.01319e-18
c353 175:qb 142:q  c=1.29779e-18
c352 175:qb 111:ln_n_61  c=1.48536e-18
c351 175:qb 143:q  c=6.74098e-19
c350 175:qb rwl  c=8.19196e-17
c349 175:qb wwl  c=1.01716e-16
c348 175:qb 68:gnd!  c=1.17746e-17
c347 175:qb 120:ln_n_63  c=7.56926e-18
c346 175:qb 95:rwl  c=3.17646e-23
cg345 174:qb 0  c=7.11148e-18
c344 174:qb 65:gnd!  c=8.60214e-20
c343 174:qb 82:gnd!  c=4.75823e-20
c342 174:qb 107:wblb  c=4.56501e-18
c341 174:qb 29:ln_n_64  c=5.14136e-17
c340 174:qb mra2|bulk  c=2.03126e-18
c339 174:qb 32:vdd!  c=8.16067e-18
c338 174:qb rwl  c=1.36932e-18
c337 174:qb mpu2|bulk  c=9.13458e-19
c336 174:qb wwl  c=1.03365e-19
c335 174:qb 95:rwl  c=4.66987e-18
c334 170:qb 117:ln_n_63  c=2.05046e-18
c333 170:qb 119:ln_n_63  c=1.42833e-22
c332 170:qb 83:gnd!  c=2.4562e-18
c331 170:qb 79:gnd!  c=6.59348e-19
c330 170:qb 26:ln_n_62  c=2.05045e-18
c329 170:qb 112:ln_n_61  c=1.54693e-20
c328 170:qb 113:ln_n_61  c=2.55086e-19
c327 170:qb 142:q  c=2.90803e-18
c326 170:qb 143:q  c=6.96305e-19
c325 170:qb 120:ln_n_63  c=2.91996e-18
c324 mpd2|drn 120:ln_n_63  c=1.23422e-17
c323 mpd2|drn 26:ln_n_62  c=1.04718e-17
c322 mpd2|drn 119:ln_n_63  c=4.36084e-18
c321 mpd2|drn mpd1|src  c=2.96394e-17
c320 mpd2|drn 65:gnd!  c=1.77411e-19
c319 mpd2|drn mpg2|src  c=2.86429e-17
c318 mpd2|drn mpg1|src  c=1.77411e-19
cg317 mpu2|drn 0  c=3.34097e-19
c316 mpu2|drn 28:ln_n_62  c=2.08182e-17
c315 mpu2|drn 120:ln_n_63  c=1.26969e-18
c314 mpu2|drn mpu1|src  c=2.8718e-17
c313 mpu2|drn 122:q  c=1.77411e-19
c312 152:qb 41:vdd!  c=1.06669e-18
c311 152:qb 28:ln_n_62  c=2.04324e-18
c310 152:qb 40:vdd!  c=2.09373e-18
cg309 150:qb 0  c=8.0099e-19
c308 150:qb 29:ln_n_64  c=3.0147e-19
cg307 146:q 0  c=1.84685e-17
c306 146:q 41:vdd!  c=6.90736e-18
c305 146:q 28:ln_n_62  c=8.12398e-19
c304 146:q 40:vdd!  c=1.46138e-18
c303 146:q 112:ln_n_61  c=2.07097e-17
c302 146:q mra2|bulk  c=8.16964e-19
c301 146:q 113:ln_n_61  c=1.03838e-17
c300 146:q 32:vdd!  c=5.1113e-17
c299 146:q 111:ln_n_61  c=1.95052e-17
c298 146:q rwl  c=8.17779e-17
c297 146:q 47:wbl  c=3.23966e-17
c296 146:q mpu2|bulk  c=1.89479e-18
cg295 145:q 0  c=6.71693e-18
c294 145:q 83:gnd!  c=1.23526e-18
c293 145:q 79:gnd!  c=1.51326e-19
c292 145:q mra2|bulk  c=7.00462e-18
c291 145:q 32:vdd!  c=3.12305e-19
c290 145:q rwl  c=5.28618e-17
c289 145:q 47:wbl  c=6.60519e-18
c288 145:q mpu2|bulk  c=6.26267e-19
c287 145:q 68:gnd!  c=2.84044e-18
c286 145:q wwl  c=5.35324e-17
c285 144:q 41:vdd!  c=2.69497e-21
c284 144:q 83:gnd!  c=2.84236e-18
c283 144:q 28:ln_n_62  c=1.35163e-17
c282 144:q 40:vdd!  c=6.47687e-21
c281 144:q 79:gnd!  c=8.29952e-21
c280 144:q 26:ln_n_62  c=1.43359e-17
c279 144:q 27:ln_n_62  c=3.98529e-17
c278 144:q mra2|bulk  c=2.74391e-18
c277 144:q 111:ln_n_61  c=1.00959e-17
c276 144:q rwl  c=1.27548e-17
c275 144:q 47:wbl  c=6.29365e-20
c274 144:q mpu2|bulk  c=1.84806e-19
c273 144:q 68:gnd!  c=1.96794e-19
c272 144:q wwl  c=1.23577e-17
c271 144:q 120:ln_n_63  c=1.81732e-19
c270 143:q 117:ln_n_63  c=1.02289e-18
c269 143:q 56:wwl  c=6.99031e-19
c268 143:q 28:ln_n_62  c=1.73008e-19
c267 143:q 26:ln_n_62  c=1.73008e-19
c266 143:q 27:ln_n_62  c=7.08748e-19
c265 143:q mra2|bulk  c=1.0207e-18
c264 143:q 32:vdd!  c=1.02873e-19
c263 143:q 111:ln_n_61  c=1.70402e-17
c262 143:q rwl  c=7.72508e-18
c261 143:q 47:wbl  c=9.30939e-18
c260 143:q 68:gnd!  c=2.32636e-19
c259 143:q wwl  c=7.95323e-18
c258 143:q 120:ln_n_63  c=6.13076e-20
c257 143:q 63:wwl  c=1.72316e-19
cg256 142:q 0  c=7.33908e-20
c255 142:q 117:ln_n_63  c=1.70416e-17
c254 142:q 56:wwl  c=2.90906e-18
c253 142:q 83:gnd!  c=1.06698e-17
c252 142:q 26:ln_n_62  c=8.56737e-19
c251 142:q mra2|bulk  c=8.22956e-19
c250 142:q 111:ln_n_61  c=3.0621e-17
c249 142:q 47:wbl  c=1.66138e-17
c248 142:q 68:gnd!  c=1.25874e-17
c247 142:q wwl  c=8.53263e-17
c246 142:q 64:wwl  c=1.78728e-18
c245 142:q 120:ln_n_63  c=8.51487e-18
c244 142:q 63:wwl  c=2.94004e-19
c243 139:q 117:ln_n_63  c=1.42833e-22
c242 139:q 119:ln_n_63  c=2.05046e-18
c241 139:q 83:gnd!  c=2.4562e-18
c240 139:q 28:ln_n_62  c=5.54833e-20
c239 139:q 79:gnd!  c=6.59348e-19
c238 139:q 27:ln_n_62  c=1.18022e-18
c237 139:q 111:ln_n_61  c=2.05045e-18
c236 139:q 120:ln_n_63  c=2.91996e-18
c235 mpg1|src 120:ln_n_63  c=1.23937e-17
c234 mpg1|src 42:wbl  c=2.8718e-17
c233 mpg1|src mpd1|src  c=2.96394e-17
c232 mpg1|src 111:ln_n_61  c=1.04718e-17
c231 mpg1|src 117:ln_n_63  c=1.04744e-17
c230 125:q 41:vdd!  c=7.26804e-20
c229 125:q 40:vdd!  c=2.19342e-18
c228 122:q 112:ln_n_61  c=1.42736e-17
c227 122:q 120:ln_n_63  c=1.26969e-18
c226 122:q mpu1|src  c=2.8718e-17
cg225 121:ln_n_63 0  c=1.43384e-17
c224 121:ln_n_63 64:wwl  c=3.66095e-17
c223 121:ln_n_63 63:wwl  c=1.95231e-18
c222 121:ln_n_63 47:wbl  c=5.6761e-20
c221 121:ln_n_63 80:gnd!  c=2.7182e-20
c220 121:ln_n_63 79:gnd!  c=5.05346e-19
c219 121:ln_n_63 mra2|bulk  c=6.08762e-18
cg218 120:ln_n_63 0  c=4.94208e-17
c217 120:ln_n_63 56:wwl  c=2.74115e-18
c216 120:ln_n_63 80:gnd!  c=3.00502e-18
c215 120:ln_n_63 83:gnd!  c=1.12441e-17
c214 120:ln_n_63 79:gnd!  c=3.37209e-17
c213 120:ln_n_63 26:ln_n_62  c=5.35821e-18
c212 120:ln_n_63 mpd1|src  c=1.21442e-17
c211 120:ln_n_63 27:ln_n_62  c=1.18936e-19
c210 120:ln_n_63 42:wbl  c=1.09049e-17
c209 120:ln_n_63 mra2|bulk  c=1.93489e-17
c208 120:ln_n_63 113:ln_n_61  c=3.81442e-19
c207 120:ln_n_63 111:ln_n_61  c=1.11999e-17
c206 120:ln_n_63 47:wbl  c=7.2512e-18
c205 120:ln_n_63 68:gnd!  c=3.36653e-18
c204 120:ln_n_63 64:wwl  c=1.69297e-17
cg203 119:ln_n_63 0  c=7.4747e-18
c202 119:ln_n_63 65:gnd!  c=5.97602e-19
c201 119:ln_n_63 82:gnd!  c=3.23827e-18
c200 119:ln_n_63 80:gnd!  c=1.78559e-18
c199 119:ln_n_63 107:wblb  c=2.25362e-17
c198 119:ln_n_63 mpg2|src  c=2.08714e-17
c197 119:ln_n_63 83:gnd!  c=9.4398e-19
c196 119:ln_n_63 79:gnd!  c=1.53014e-18
c195 119:ln_n_63 26:ln_n_62  c=1.22014e-17
c194 119:ln_n_63 mra2|bulk  c=1.16406e-17
c193 119:ln_n_63 111:ln_n_61  c=4.72549e-19
c192 119:ln_n_63 wwl  c=1.29881e-18
c191 119:ln_n_63 68:gnd!  c=1.32245e-18
cg190 117:ln_n_63 0  c=5.62222e-18
c189 117:ln_n_63 83:gnd!  c=7.43948e-19
c188 117:ln_n_63 79:gnd!  c=6.87492e-19
c187 117:ln_n_63 26:ln_n_62  c=3.54163e-19
c186 117:ln_n_63 42:wbl  c=1.42757e-17
c185 117:ln_n_63 mra2|bulk  c=1.08668e-17
c184 117:ln_n_63 111:ln_n_61  c=1.43664e-17
c183 117:ln_n_63 47:wbl  c=1.94395e-17
c182 117:ln_n_63 wwl  c=1.29881e-18
c181 117:ln_n_63 68:gnd!  c=6.61225e-19
c180 117:ln_n_63 64:wwl  c=6.27637e-18
c179 117:ln_n_63 63:wwl  c=2.14164e-19
cg178 mra2|bulk 0  c=5.38956e-18
c177 mra2|bulk 114:ln_n_65  c=1.72463e-17
c176 mra2|bulk 82:gnd!  c=4.69583e-18
c175 mra2|bulk 80:gnd!  c=4.85261e-18
c174 mra2|bulk 107:wblb  c=1.49391e-17
c173 mra2|bulk 116:ln_n_65  c=7.08299e-18
c172 mra2|bulk 115:ln_n_65  c=3.90905e-18
c171 mra2|bulk 30:ln_n_64  c=3.04495e-17
c170 mra2|bulk 29:ln_n_64  c=1.06708e-17
c169 mra2|bulk 41:vdd!  c=5.055e-19
c168 mra2|bulk 83:gnd!  c=2.97346e-18
c167 mra2|bulk 28:ln_n_62  c=1.45145e-17
c166 mra2|bulk 40:vdd!  c=1.50582e-19
c165 mra2|bulk 79:gnd!  c=3.49281e-18
c164 mra2|bulk 26:ln_n_62  c=1.2247e-17
c163 mra2|bulk 27:ln_n_62  c=7.92694e-18
c162 mra2|bulk 112:ln_n_61  c=2.43198e-19
c161 mra2|bulk 113:ln_n_61  c=6.96544e-18
c160 mra2|bulk 32:vdd!  c=1.75795e-17
c159 mra2|bulk 111:ln_n_61  c=2.7538e-17
c158 mra2|bulk rwl  c=2.37896e-17
c157 mra2|bulk 47:wbl  c=1.28743e-17
c156 mra2|bulk wwl  c=2.16524e-17
c155 mra2|bulk 68:gnd!  c=2.97372e-17
c154 mra2|bulk 64:wwl  c=4.35979e-18
c153 mra2|bulk 63:wwl  c=4.68985e-18
c152 mra2|bulk 101:rbl  c=1.71739e-17
c151 mra2|bulk 95:rwl  c=1.97422e-18
cg150 116:ln_n_65 0  c=7.42423e-18
c149 116:ln_n_65 110:net5  c=1.54511e-17
c148 116:ln_n_65 30:ln_n_64  c=1.21674e-17
c147 116:ln_n_65 mra2|drn  c=2.07401e-17
c146 116:ln_n_65 mra1|drn  c=4.35855e-18
c145 116:ln_n_65 101:rbl  c=2.14036e-17
cg144 115:ln_n_65 0  c=4.94484e-18
c143 115:ln_n_65 95:rwl  c=1.15921e-17
c142 115:ln_n_65 30:ln_n_64  c=2.77122e-18
c141 115:ln_n_65 101:rbl  c=1.72138e-18
cg140 114:ln_n_65 0  c=1.30058e-17
c139 114:ln_n_65 110:net5  c=1.11545e-18
c138 114:ln_n_65 95:rwl  c=4.62321e-17
c137 114:ln_n_65 30:ln_n_64  c=4.09833e-17
c136 114:ln_n_65 101:rbl  c=4.36605e-17
c135 114:ln_n_65 86:rwl  c=3.82601e-18
c134 114:ln_n_65 mra1|drn  c=1.69619e-18
cg133 113:ln_n_61 0  c=5.43364e-18
c132 113:ln_n_61 41:vdd!  c=2.89275e-18
c131 113:ln_n_61 83:gnd!  c=2.29551e-19
c130 113:ln_n_61 28:ln_n_62  c=2.13518e-17
c129 113:ln_n_61 mpd1|src  c=8.21128e-19
c128 113:ln_n_61 mpu2|bulk  c=1.51859e-18
c127 113:ln_n_61 mpu1|src  c=8.36698e-18
cg126 112:ln_n_61 0  c=1.15218e-17
c125 112:ln_n_61 41:vdd!  c=9.23429e-18
c124 112:ln_n_61 28:ln_n_62  c=1.38757e-17
c123 112:ln_n_61 40:vdd!  c=9.062e-18
c122 112:ln_n_61 32:vdd!  c=5.45446e-19
c121 112:ln_n_61 mpu2|bulk  c=9.02174e-18
c120 112:ln_n_61 mpu1|src  c=1.04695e-17
cg119 111:ln_n_61 0  c=1.81012e-17
c118 111:ln_n_61 83:gnd!  c=1.61368e-17
c117 111:ln_n_61 28:ln_n_62  c=1.54774e-17
c116 111:ln_n_61 79:gnd!  c=1.32013e-18
c115 111:ln_n_61 26:ln_n_62  c=2.328e-17
c114 111:ln_n_61 27:ln_n_62  c=1.59518e-17
c113 111:ln_n_61 mpd1|src  c=1.04718e-17
c112 111:ln_n_61 68:gnd!  c=4.4055e-19
cg111 110:net5 0  c=2.44503e-17
c110 110:net5 82:gnd!  c=1.35773e-17
c109 110:net5 30:ln_n_64  c=1.63523e-17
c108 110:net5 29:ln_n_64  c=2.99821e-19
c107 110:net5 83:gnd!  c=1.10747e-24
c106 110:net5 68:gnd!  c=1.72678e-17
c105 110:net5 wwl  c=3.38573e-17
c104 110:net5 101:rbl  c=1.47043e-17
cg103 mra1|drn 0  c=7.03949e-19
c102 mra1|drn 30:ln_n_64  c=1.04514e-17
c101 mra1|drn 29:ln_n_64  c=4.3299e-19
c100 mra1|drn 65:gnd!  c=2.86429e-17
c99 mra1|drn mra2|drn  c=2.8718e-17
cg98 107:wblb 0  c=4.23116e-17
c97 107:wblb 60:wwl  c=3.65572e-18
c96 107:wblb 82:gnd!  c=1.47683e-17
c95 107:wblb 30:ln_n_64  c=2.12249e-17
c94 107:wblb 29:ln_n_64  c=4.16054e-18
c93 107:wblb 41:vdd!  c=9.1566e-19
c92 107:wblb 83:gnd!  c=9.41813e-19
c91 107:wblb 40:vdd!  c=1.59518e-18
c90 107:wblb 32:vdd!  c=1.24029e-16
c89 107:wblb rwl  c=9.59343e-17
c88 107:wblb mpu2|bulk  c=8.17791e-18
c87 107:wblb wwl  c=1.06949e-16
c86 107:wblb 68:gnd!  c=1.2892e-17
c85 107:wblb 95:rwl  c=5.02313e-19
cg84 mpg2|src 0  c=1.77411e-19
c83 mpg2|src 30:ln_n_64  c=5.97602e-19
c82 mpg2|src mpd1|src  c=1.77411e-19
c81 mpg2|src 65:gnd!  c=2.54588e-17
cg80 101:rbl 0  c=1.00413e-16
c79 101:rbl 86:rwl  c=2.7817e-18
c78 101:rbl 32:vdd!  c=1.26889e-16
c77 101:rbl rwl  c=9.76039e-17
c76 101:rbl mpu2|bulk  c=4.35847e-18
c75 101:rbl wwl  c=1.09724e-16
c74 101:rbl 95:rwl  c=2.70634e-17
cg73 mra2|drn 0  c=1.77411e-19
c72 mra2|drn 95:rwl  c=3.87742e-20
c71 95:rwl 30:ln_n_64  c=1.1961e-17
c70 95:rwl 29:ln_n_64  c=9.43857e-19
c69 95:rwl 32:vdd!  c=1.79149e-18
c68 95:rwl wwl  c=4.27551e-18
c67 rwl 41:vdd!  c=4.50299e-20
c66 rwl 40:vdd!  c=8.22622e-20
c65 rwl 32:vdd!  c=2.70317e-17
c64 rwl 47:wbl  c=1.09489e-16
c63 rwl mpu2|bulk  c=3.65242e-18
c62 rwl wwl  c=5.28348e-17
c61 rwl 63:wwl  c=7.91324e-18
c60 86:rwl 30:ln_n_64  c=2.07945e-18
c59 83:gnd! 26:ln_n_62  c=1.33746e-17
c58 83:gnd! 27:ln_n_62  c=1.21359e-18
c57 83:gnd! wwl  c=2.45472e-17
c56 83:gnd! 64:wwl  c=9.29285e-20
cg55 82:gnd! 0  c=8.12364e-18
c54 82:gnd! 30:ln_n_64  c=1.77763e-17
c53 82:gnd! 26:ln_n_62  c=6.45395e-20
c52 82:gnd! wwl  c=2.53199e-17
cg51 80:gnd! 0  c=7.55001e-18
c50 80:gnd! 30:ln_n_64  c=4.07927e-19
c49 80:gnd! 26:ln_n_62  c=2.06437e-20
c48 80:gnd! wwl  c=2.15948e-19
cg47 79:gnd! 0  c=4.36136e-19
c46 79:gnd! 26:ln_n_62  c=3.55474e-19
c45 79:gnd! wwl  c=3.88091e-19
c44 79:gnd! 64:wwl  c=2.48677e-19
cg43 68:gnd! 0  c=1.4184e-16
c42 68:gnd! 56:wwl  c=1.13181e-19
c41 68:gnd! wwl  c=5.01744e-17
c40 68:gnd! 64:wwl  c=9.61536e-17
c39 68:gnd! 63:wwl  c=3.989e-18
cg38 mpd1|src 0  c=9.73764e-19
c37 mpd1|src 27:ln_n_62  c=1.92738e-18
c36 mpd1|src 26:ln_n_62  c=4.35818e-18
c35 65:gnd! 30:ln_n_64  c=1.42716e-17
c34 65:gnd! 29:ln_n_64  c=5.41337e-19
cg33 64:wwl 0  c=1.17913e-17
c32 64:wwl 47:wbl  c=2.38855e-17
c31 63:wwl 47:wbl  c=2.3409e-17
c30 63:wwl mpu2|bulk  c=7.64271e-19
c29 56:wwl 47:wbl  c=3.39928e-18
c28 wwl 47:wbl  c=9.40519e-17
c27 wwl mpu2|bulk  c=1.78308e-18
cg26 47:wbl 0  c=6.41132e-17
c25 47:wbl 41:vdd!  c=9.29552e-19
c24 47:wbl 40:vdd!  c=1.69452e-18
c23 47:wbl 32:vdd!  c=1.22479e-16
c22 47:wbl mpu2|bulk  c=1.02866e-17
cg21 42:wbl 0  c=1.77411e-19
cg20 41:vdd! 0  c=2.10613e-19
c19 41:vdd! 28:ln_n_62  c=8.02777e-18
c18 41:vdd! mpu2|bulk  c=1.68578e-19
cg17 40:vdd! 0  c=3.62749e-18
c16 40:vdd! 28:ln_n_62  c=7.87458e-18
c15 40:vdd! mpu2|bulk  c=2.61558e-18
cg14 32:vdd! 0  c=7.16438e-17
c13 32:vdd! 28:ln_n_62  c=5.45446e-19
c12 32:vdd! mpu2|bulk  c=1.42311e-17
cg11 mpu1|src 0  c=9.41392e-19
c10 mpu1|src 28:ln_n_62  c=4.36029e-18
c9 mpu1|src 27:ln_n_62  c=1.19409e-18
cg8 mpu2|bulk 0  c=4.62288e-18
c7 mpu2|bulk 28:ln_n_62  c=1.06642e-17
c6 mpu2|bulk 27:ln_n_62  c=4.17823e-19
cg5 30:ln_n_64 0  c=2.41178e-17
cg4 29:ln_n_64 0  c=1.61438e-17
cg3 28:ln_n_62 0  c=2.0337e-17
cg2 27:ln_n_62 0  c=6.68693e-18
cg1 26:ln_n_62 0  c=6.80957e-18
mra2 mra2|drn mra2|gate mra2|src mra2|bulk N w=0.2u l=0.1u nf=1 m=1 ad=0.044p
+ as=0.025p pd=0.84u ps=0.45u nrd=1.15789 nrs=1.15789 sa=0.22u sb=0.22u sd=0u
mra1 mra1|drn mra1|gate mra1|src mra1|bulk N w=0.2u l=0.1u nf=1 m=1 ad=0.025p
+ as=0.044p pd=0.45u ps=0.84u nrd=1.15789 nrs=1.15789 sa=0.22u sb=0.22u sd=0u
mpg2 mpg2|drn mpg2|gate mpg2|src mpg2|bulk N w=0.2u l=0.1u nf=1 m=1 ad=0.025p
+ as=0.044p pd=0.45u ps=0.84u nrd=1.15789 nrs=1.15789 sa=0.22u sb=0.22u sd=0u
mpg1 mpg1|drn mpg1|gate mpg1|src mpg1|bulk N w=0.2u l=0.1u nf=1 m=1 ad=0.044p
+ as=0.025p pd=0.84u ps=0.45u nrd=1.15789 nrs=1.15789 sa=0.22u sb=0.22u sd=0u
mpd2 mpd2|drn mpd2|gate mpd2|src mpd2|bulk N w=0.2u l=0.1u nf=1 m=1 ad=0.025p
+ as=0.025p pd=0.45u ps=0.45u nrd=1.15789 nrs=1.15789 sa=0.22u sb=0.22u sd=0u
mpd1 mpd1|drn mpd1|gate mpd1|src mpd1|bulk N w=0.2u l=0.1u nf=1 m=1 ad=0.025p
+ as=0.025p pd=0.45u ps=0.45u nrd=1.15789 nrs=1.15789 sa=0.22u sb=0.22u sd=0u
mpu2 mpu2|drn mpu2|gate mpu2|src mpu2|bulk P w=0.2u l=0.1u nf=1 m=1 ad=0.044p
+ as=0.025p pd=0.84u ps=0.45u nrd=1.15789 nrs=1.15789 sa=0.22u sb=0.22u sd=0u
mpu1 mpu1|drn mpu1|gate mpu1|src mpu1|bulk P w=0.2u l=0.1u nf=1 m=1 ad=0.044p
+ as=0.025p pd=0.84u ps=0.45u nrd=1.15789 nrs=1.15789 sa=0.22u sb=0.22u sd=0u
.ends ram8t_cell

********************************************************************************
* Library          : ram8t_custom
* Cell             : ram8t_cell_test
* View             : schematic
* View Search List : schematic hspice symbol
* View Stop List   : symbol
********************************************************************************
c0 rbl gnd! c=10f
m0 rbl pre vdd! vdd! P w=0.2u l=0.1u nf=1 m=1 ad=44f as=44f pd=0.64u ps=0.64u
+ nrd=1.1 nrs=1.1 sa=0.22u sb=0.22u sd=0
vpre pre gnd! dc=0 pulse ( 0 0.8 5.5n 100p 100p 3n 10n )
vwblb wblb gnd! dc=0 pulse ( 0.8 0 0 100p 100p 9.9n 20n )
vwbl wbl gnd! dc=0 pulse ( 0 0.8 0 100p 100p 9.9n 20n )
vwwl wwl gnd! dc=0 pulse ( 0 0.8 1n 100p 100p 2n 10n )
vrwl rwl gnd! dc=0 pulse ( 0 0.8 6n 100p 100p 2n 10n )
v0 vdd! gnd! dc=0.8
xi0 rbl rwl wbl wblb wwl ram8t_cell

.tran 10p 20n start=0
.option opfile=1 split_dp=1
.option probe=1
.probe tran v(*) level=1
.probe tran Q=v(xi0.q) v(xi0.q) QB=v(xi0.qb) v(xi0.qb) PRE=v(pre) v(pre)
+ RBL=v(rbl) v(rbl) RWL=v(rwl) v(rwl) WBL=v(wbl) v(wbl) WBLB=v(wblb) v(wblb)
+ WWL=v(wwl) v(wwl)

.measure tran sample_1 find v(rbl) at=7.5n
.measure tran sample_2 find v(rbl) at=17.5n
.end

* Initial state for ram8t_cell_test (schematic): Q=0, QB=VDD, so the first write-1 flips the cell
.ic v(xi0.q)=0 v(xi0.qb)=0.8

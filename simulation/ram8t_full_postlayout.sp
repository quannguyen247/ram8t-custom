*  Generated for: HSPICE
*  Design library name: ram8t_custom
*  Design cell name: ram8t_full_test
*  Design view name: config

.option PARHIER = LOCAL
.option PORT_VOLTAGE_SCALE_TO_2X = 1

.option ARTIST=2 PSF=2
.temp 25
.include 'reference_models.inc'
*Custom Compiler Version N-2017.12-SP1-2
*Sun Nov 22 11:50:11 2026

.GLOBAL 0 gnd! vdd!
********************************************************************************
* Library          : ram8t_custom
* Cell             : ram8t_full
* View             : starrc
* View Search List : schematic hspice symbol
* View Stop List   : symbol
********************************************************************************
.subckt ram8t_full a din0 din1 dout0 dout1 preb re we
r1776 xxarr|xi2|mpu2|bulk xxarr|xi0|mpu1|bulk  r=0.001
r1775 xxarr|xi2|mpu2|bulk xxarr|xi2|mpu1|bulk  r=0.001
r1774 ln_xarr|n_13 xxarr|xi0|mpu2|bulk  r=0.001
r1773 ln_xarr|n_13 xxarr|xi2|mpu2|bulk  r=0.001
r1772 1443:ln_n_15 1444:ln_n_15  r=0.001
r1771 1443:ln_n_15 1445:ln_n_15  r=0.001
r1770 1430:ln_n_15 xxdec|xn3|mm1|bulk  r=0.001
r1769 1430:ln_n_15 xxdec|xn3|mm0|bulk  r=0.001
r1768 1430:ln_n_15 1431:ln_n_15  r=0.001
r1767 1430:ln_n_15 1432:ln_n_15  r=0.001
r1766 1430:ln_n_15 xxrs0|xis1|mm0|bulk  r=0.001
r1765 1430:ln_n_15 1433:ln_n_15  r=0.001
r1764 1430:ln_n_15 1434:ln_n_15  r=0.001
r1763 1430:ln_n_15 1437:ln_n_15  r=0.001
r1762 1430:ln_n_15 1438:ln_n_15  r=0.001
r1761 1430:ln_n_15 1435:ln_n_15  r=0.001
r1760 1430:ln_n_15 xxdec|xi0|mm0|bulk  r=0.001
r1759 1430:ln_n_15 1436:ln_n_15  r=0.001
r1758 1430:ln_n_15 1442:ln_n_15  r=0.001
r1757 1430:ln_n_15 xxdec|xi1|mm0|bulk  r=0.001
r1756 1430:ln_n_15 1441:ln_n_15  r=0.001
r1755 1430:ln_n_15 xxdec|xi2|mm0|bulk  r=0.001
r1754 1430:ln_n_15 1440:ln_n_15  r=0.001
r1753 1430:ln_n_15 1443:ln_n_15  r=0.001
r1752 1430:ln_n_15 xxdec|xi3|mm0|bulk  r=0.001
r1751 1430:ln_n_15 1439:ln_n_15  r=0.001
r1750 1430:ln_n_15 xxdec|xi4|mm0|bulk  r=0.001
r1749 1430:ln_n_15 xxdec|xn0|mm1|bulk  r=0.001
r1748 1430:ln_n_15 xxdec|xn0|mm0|bulk  r=0.001
r1747 1430:ln_n_15 xxdec|xn1|mm1|bulk  r=0.001
r1746 1430:ln_n_15 xxdec|xn1|mm0|bulk  r=0.001
r1745 1430:ln_n_15 xxdec|xn2|mm1|bulk  r=0.001
r1744 1430:ln_n_15 xxdec|xn2|mm0|bulk  r=0.001
r1743 1421:ln_n_15 1443:ln_n_15  r=0.001
r1742 xxwd0|xi1|mm0|bulk xxrs0|xis2|mm0|bulk  r=0.001
r1741 xxwd0|xi1|mm0|bulk 1429:ln_n_15  r=0.001
r1740 xxwd0|xi1|mm0|bulk 1430:ln_n_15  r=0.001
r1739 1420:ln_n_15 1421:ln_n_15  r=0.001
r1738 xxarr|xi3|mra1|bulk xxwd0|xi1|mm0|bulk  r=0.001
r1737 xxarr|xi3|mra1|bulk xxarr|xi1|mpg1|bulk  r=0.001
r1736 xxarr|xi3|mra1|bulk 1427:ln_n_15  r=0.001
r1735 xxarr|xi3|mra1|bulk xxarr|xi1|mpd2|bulk  r=0.001
r1734 xxarr|xi3|mra1|bulk 1423:ln_n_15  r=0.001
r1733 xxarr|xi3|mra1|bulk xxarr|xi1|mpd1|bulk  r=0.001
r1732 xxarr|xi3|mra1|bulk xxarr|xi1|mra2|bulk  r=0.001
r1731 xxarr|xi3|mra1|bulk xxrs1|xis1|mm0|bulk  r=0.001
r1730 xxarr|xi3|mra1|bulk 1422:ln_n_15  r=0.001
r1729 xxarr|xi3|mra1|bulk xxarr|xi1|mra1|bulk  r=0.001
r1728 xxarr|xi3|mra1|bulk 1428:ln_n_15  r=0.001
r1727 xxarr|xi3|mra1|bulk 1426:ln_n_15  r=0.001
r1726 xxarr|xi3|mra1|bulk xxwd1|xi0|mm0|bulk  r=0.001
r1725 xxarr|xi3|mra1|bulk xxarr|xi3|mpg2|bulk  r=0.001
r1724 xxarr|xi3|mra1|bulk xxarr|xi0|mpg2|bulk  r=0.001
r1723 xxarr|xi3|mra1|bulk xxarr|xi3|mpg1|bulk  r=0.001
r1722 xxarr|xi3|mra1|bulk xxarr|xi0|mpg1|bulk  r=0.001
r1721 xxarr|xi3|mra1|bulk xxrs1|xis2|mm0|bulk  r=0.001
r1720 xxarr|xi3|mra1|bulk 1424:ln_n_15  r=0.001
r1719 xxarr|xi3|mra1|bulk xxarr|xi3|mpd2|bulk  r=0.001
r1718 xxarr|xi3|mra1|bulk xxarr|xi0|mpd2|bulk  r=0.001
r1717 xxarr|xi3|mra1|bulk xxarr|xi3|mpd1|bulk  r=0.001
r1716 xxarr|xi3|mra1|bulk xxarr|xi0|mpd1|bulk  r=0.001
r1715 xxarr|xi3|mra1|bulk xxarr|xi3|mra2|bulk  r=0.001
r1714 xxarr|xi3|mra1|bulk xxwd1|xi1|mm0|bulk  r=0.001
r1713 xxarr|xi3|mra1|bulk xxarr|xi0|mra2|bulk  r=0.001
r1712 xxarr|xi3|mra1|bulk xxarr|xi0|mra1|bulk  r=0.001
r1711 xxarr|xi3|mra1|bulk 1425:ln_n_15  r=0.001
r1710 xxarr|xi3|mra1|bulk xxarr|xi2|mpg2|bulk  r=0.001
r1709 xxarr|xi3|mra1|bulk xxarr|xi2|mpg1|bulk  r=0.001
r1708 xxarr|xi3|mra1|bulk xxarr|xi2|mpd2|bulk  r=0.001
r1707 xxarr|xi3|mra1|bulk xxwd0|xi0|mm0|bulk  r=0.001
r1706 xxarr|xi3|mra1|bulk xxarr|xi2|mpd1|bulk  r=0.001
r1705 xxarr|xi3|mra1|bulk xxarr|xi2|mra2|bulk  r=0.001
r1704 xxarr|xi3|mra1|bulk xxarr|xi2|mra1|bulk  r=0.001
r1703 ln_n_15 xxarr|xi1|mpg2|bulk  r=0.001
r1702 ln_n_15 xxarr|xi3|mra1|bulk  r=0.001
r1701 xxarr|xi3|mpu2|bulk xxarr|xi1|mpu1|bulk  r=0.001
r1700 xxarr|xi3|mpu2|bulk xxarr|xi1|mpu2|bulk  r=0.001
r1699 ln_xarr|n_14 xxarr|xi3|mpu1|bulk  r=0.001
r1698 ln_xarr|n_14 xxarr|xi3|mpu2|bulk  r=0.001
r1697 xxdec|xi0|mm1|bulk xxdec|xi4|mm1|bulk  r=0.001
r1696 xxdec|xi0|mm1|bulk 1417:ln_xdec|n_22  r=0.001
r1695 xxdec|xi0|mm1|bulk xxdec|xn1|mm3|bulk  r=0.001
r1694 xxdec|xi0|mm1|bulk xxdec|xn1|mm2|bulk  r=0.001
r1693 xxdec|xi0|mm1|bulk xxdec|xn3|mm3|bulk  r=0.001
r1692 xxdec|xi0|mm1|bulk xxdec|xi2|mm1|bulk  r=0.001
r1691 xxdec|xi0|mm1|bulk 1419:ln_xdec|n_22  r=0.001
r1690 xxdec|xi0|mm1|bulk xxdec|xn3|mm2|bulk  r=0.001
r1689 xxdec|xi0|mm1|bulk 1416:ln_xdec|n_22  r=0.001
r1688 xxdec|xi0|mm1|bulk xxdec|xn0|mm3|bulk  r=0.001
r1687 xxdec|xi0|mm1|bulk xxdec|xn0|mm2|bulk  r=0.001
r1686 xxdec|xi0|mm1|bulk xxdec|xi3|mm1|bulk  r=0.001
r1685 xxdec|xi0|mm1|bulk xxdec|xn2|mm3|bulk  r=0.001
r1684 xxdec|xi0|mm1|bulk 1418:ln_xdec|n_22  r=0.001
r1683 xxdec|xi0|mm1|bulk xxdec|xn2|mm2|bulk  r=0.001
r1682 xxdec|xi0|mm1|bulk 1415:ln_xdec|n_22  r=0.001
r1681 ln_xdec|n_22 xxdec|xi1|mm1|bulk  r=0.001
r1680 ln_xdec|n_22 xxdec|xi0|mm1|bulk  r=0.001
r1679 xxrs1|mmpre|bulk 1412:ln_n_18  r=0.001
r1678 xxrs1|mmpre|bulk 1413:ln_n_18  r=0.001
r1677 xxrs1|mmpre|bulk xxrs1|xis2|mm1|bulk  r=0.001
r1676 xxrs1|mmpre|bulk 1414:ln_n_18  r=0.001
r1675 xxrs1|mmpre|bulk xxrs0|xis1|mm1|bulk  r=0.001
r1674 xxrs1|mmpre|bulk 1411:ln_n_18  r=0.001
r1673 xxrs1|mmpre|bulk xxrs0|xis2|mm1|bulk  r=0.001
r1672 xxrs1|mmpre|bulk xxrs0|mmpre|bulk  r=0.001
r1671 ln_n_18 xxrs1|xis1|mm1|bulk  r=0.001
r1670 ln_n_18 xxrs1|mmpre|bulk  r=0.001
r1669 1409:ln_xarr|x_r1c0|n_65 1410:ln_xarr|x_r1c0|n_65  r=41.4
r1668 1407:ln_xarr|x_r1c0|n_65 1408:ln_xarr|x_r1c0|n_65  r=5.37288
r1667 ln_xarr|x_r1c0|n_65 1407:ln_xarr|x_r1c0|n_65  r=57.5527
r1666 ln_xarr|x_r1c0|n_65 1409:ln_xarr|x_r1c0|n_65  r=0.001
r1665 xxwd0|xi1|mm1|bulk 1404:ln_n_19  r=0.001
r1664 xxwd0|xi1|mm1|bulk 1403:ln_n_19  r=0.001
r1663 xxwd0|xi0|mm1|bulk 1406:ln_n_19  r=0.001
r1662 xxwd0|xi0|mm1|bulk 1405:ln_n_19  r=0.001
r1661 xxwd0|xi0|mm1|bulk xxwd0|xi1|mm1|bulk  r=0.001
r1660 xxwd0|xi0|mm1|bulk xxwd1|xi0|mm1|bulk  r=0.001
r1659 ln_n_19 xxwd1|xi1|mm1|bulk  r=0.001
r1658 ln_n_19 xxwd0|xi0|mm1|bulk  r=0.001
r1657 1394:xxrs1|net7 1400:xxrs1|net7  r=0.098
r1656 1394:xxrs1|net7 1396:xxrs1|net7  r=0.098
r1655 1394:xxrs1|net7 1395:xxrs1|net7  r=0.098
r1654 1390:xxrs1|net7 1398:xxrs1|net7  r=0.05
r1653 1390:xxrs1|net7 1397:xxrs1|net7  r=0.05
r1652 1389:xxrs1|net7 1394:xxrs1|net7  r=0.891333
r1651 1389:xxrs1|net7 1393:xxrs1|net7  r=0.098
r1650 1389:xxrs1|net7 1392:xxrs1|net7  r=0.098
r1649 1389:xxrs1|net7 1391:xxrs1|net7  r=0.098
r1648 1389:xxrs1|net7 1390:xxrs1|net7  r=2
r1647 1387:xxrs1|net7 1397:xxrs1|net7  r=0.546
r1646 1387:xxrs1|net7 1388:xxrs1|net7  r=0.119
r1645 1387:xxrs1|net7 xxrs1|xis1|mm0|drn  r=18
r1644 1386:xxrs1|net7 1398:xxrs1|net7  r=0.49
r1643 1385:xxrs1|net7 1386:xxrs1|net7  r=0.266
r1642 1384:xxrs1|net7 1385:xxrs1|net7  r=0.266
r1641 1383:xxrs1|net7 1384:xxrs1|net7  r=0.266
r1640 xxrs1|xis1|mm1|drn 1386:xxrs1|net7  r=18
r1639 xxrs1|xis1|mm1|drn 1385:xxrs1|net7  r=18
r1638 xxrs1|xis1|mm1|drn 1384:xxrs1|net7  r=18
r1637 xxrs1|xis1|mm1|drn 1383:xxrs1|net7  r=18
r1636 1382:xxrs1|net7 1401:xxrs1|net7  r=0.119
r1635 1382:xxrs1|net7 1383:xxrs1|net7  r=0.266
r1634 1382:xxrs1|net7 xxrs1|xis1|mm1|drn  r=18
r1633 xxrs1|xis2|mm1|gate 1399:xxrs1|net7  r=13.51
r1632 1381:xxrs1|net7 xxrs1|xis2|mm1|gate  r=12.95
r1631 1380:xxrs1|net7 1402:xxrs1|net7  r=0.07
r1630 1380:xxrs1|net7 xxrs1|net7  r=0.07
r1629 1380:xxrs1|net7 1394:xxrs1|net7  r=2
r1628 1379:xxrs1|net7 1381:xxrs1|net7  r=7.12501
r1627 1379:xxrs1|net7 1380:xxrs1|net7  r=18
r1626 1379:xxrs1|net7 xxrs1|xis2|mm0|gate  r=11.625
r1625 xxrs0|net7 1372:xxrs0|net7  r=0.05
r1624 xxrs0|net7 1371:xxrs0|net7  r=0.05
r1623 1368:xxrs0|net7 1375:xxrs0|net7  r=0.098
r1622 1368:xxrs0|net7 1374:xxrs0|net7  r=0.098
r1621 1368:xxrs0|net7 1369:xxrs0|net7  r=0.098
r1620 1368:xxrs0|net7 xxrs0|net7  r=2
r1619 1365:xxrs0|net7 1376:xxrs0|net7  r=0.098
r1618 1365:xxrs0|net7 1373:xxrs0|net7  r=0.098
r1617 1365:xxrs0|net7 1368:xxrs0|net7  r=0.891333
r1616 1365:xxrs0|net7 1367:xxrs0|net7  r=0.098
r1615 1363:xxrs0|net7 1371:xxrs0|net7  r=0.546
r1614 1363:xxrs0|net7 1364:xxrs0|net7  r=0.119
r1613 1363:xxrs0|net7 xxrs0|xis1|mm0|drn  r=18
r1612 1362:xxrs0|net7 1372:xxrs0|net7  r=0.49
r1611 1361:xxrs0|net7 1362:xxrs0|net7  r=0.266
r1610 1360:xxrs0|net7 1361:xxrs0|net7  r=0.266
r1609 1359:xxrs0|net7 1360:xxrs0|net7  r=0.266
r1608 xxrs0|xis1|mm1|drn 1362:xxrs0|net7  r=18
r1607 xxrs0|xis1|mm1|drn 1361:xxrs0|net7  r=18
r1606 xxrs0|xis1|mm1|drn 1360:xxrs0|net7  r=18
r1605 xxrs0|xis1|mm1|drn 1359:xxrs0|net7  r=18
r1604 1358:xxrs0|net7 1377:xxrs0|net7  r=0.119
r1603 1358:xxrs0|net7 1359:xxrs0|net7  r=0.266
r1602 1358:xxrs0|net7 xxrs0|xis1|mm1|drn  r=18
r1601 xxrs0|xis2|mm1|gate 1370:xxrs0|net7  r=13.51
r1600 1357:xxrs0|net7 xxrs0|xis2|mm1|gate  r=12.95
r1599 1356:xxrs0|net7 1378:xxrs0|net7  r=0.07
r1598 1356:xxrs0|net7 1366:xxrs0|net7  r=0.07
r1597 1356:xxrs0|net7 1365:xxrs0|net7  r=2
r1596 1355:xxrs0|net7 1357:xxrs0|net7  r=7.12501
r1595 1355:xxrs0|net7 1356:xxrs0|net7  r=18
r1594 1355:xxrs0|net7 xxrs0|xis2|mm0|gate  r=11.625
r1593 1353:xxdec|xn3|net18 1354:xxdec|xn3|net18  r=0.132632
r1592 1353:xxdec|xn3|net18 xxdec|xn3|net18  r=0.132632
r1591 xxdec|xn3|mm0|drn 1353:xxdec|xn3|net18  r=18
r1590 xxdec|xn3|mm0|drn xxdec|xn3|mm1|src  r=0.001
r1589 1351:xxdec|xn2|net18 1352:xxdec|xn2|net18  r=0.132632
r1588 1351:xxdec|xn2|net18 xxdec|xn2|net18  r=0.132632
r1587 xxdec|xn2|mm0|drn 1351:xxdec|xn2|net18  r=18
r1586 xxdec|xn2|mm0|drn xxdec|xn2|mm1|src  r=0.001
r1585 1349:xxdec|xn1|net18 1350:xxdec|xn1|net18  r=0.132632
r1584 1349:xxdec|xn1|net18 xxdec|xn1|net18  r=0.132632
r1583 xxdec|xn1|mm0|drn 1349:xxdec|xn1|net18  r=18
r1582 xxdec|xn1|mm0|drn xxdec|xn1|mm1|src  r=0.001
r1581 1347:xxdec|xn0|net18 1348:xxdec|xn0|net18  r=0.132632
r1580 1347:xxdec|xn0|net18 xxdec|xn0|net18  r=0.132632
r1579 xxdec|xn0|mm0|drn 1347:xxdec|xn0|net18  r=18
r1578 xxdec|xn0|mm0|drn xxdec|xn0|mm1|src  r=0.001
r1577 1344:ln_xdec|n_21 1345:ln_xdec|n_21  r=0.001
r1576 1344:ln_xdec|n_21 1346:ln_xdec|n_21  r=0.1
r1575 1343:ln_xdec|n_21 1344:ln_xdec|n_21  r=0.001
r1574 1342:ln_xdec|n_21 1343:ln_xdec|n_21  r=0.001
r1573 ln_xdec|n_21 1342:ln_xdec|n_21  r=0.001
r1572 ln_xdec|n_21 1346:ln_xdec|n_21  r=0.001
r1571 1335:xxdec|net20 1341:xxdec|net20  r=0.098
r1570 1335:xxdec|net20 1336:xxdec|net20  r=0.098
r1569 1334:xxdec|net20 xxdec|net20  r=0.098
r1568 1334:xxdec|net20 1335:xxdec|net20  r=2
r1567 1331:xxdec|net20 1333:xxdec|net20  r=0.098
r1566 1331:xxdec|net20 1332:xxdec|net20  r=0.098
r1565 1330:xxdec|net20 1331:xxdec|net20  r=2
r1564 1327:xxdec|net20 1328:xxdec|net20  r=0.119
r1563 1326:xxdec|net20 1327:xxdec|net20  r=0.266
r1562 1325:xxdec|net20 1326:xxdec|net20  r=0.266
r1561 1324:xxdec|net20 1325:xxdec|net20  r=0.266
r1560 1323:xxdec|net20 1336:xxdec|net20  r=0.525
r1559 1323:xxdec|net20 1324:xxdec|net20  r=0.266
r1558 1322:xxdec|net20 1340:xxdec|net20  r=0.119
r1557 1322:xxdec|net20 1333:xxdec|net20  r=0.427
r1556 1320:xxdec|net20 1338:xxdec|net20  r=0.07
r1555 1320:xxdec|net20 1329:xxdec|net20  r=0.07
r1554 1319:xxdec|net20 1339:xxdec|net20  r=0.098
r1553 1319:xxdec|net20 1337:xxdec|net20  r=0.098
r1552 1319:xxdec|net20 1330:xxdec|net20  r=0.445666
r1551 1319:xxdec|net20 1320:xxdec|net20  r=2
r1550 1318:xxdec|net20 1319:xxdec|net20  r=0.0629066
r1549 1317:xxdec|net20 1334:xxdec|net20  r=0.527333
r1548 1317:xxdec|net20 1330:xxdec|net20  r=0.042
r1547 xxdec|xn3|mm2|drn 1327:xxdec|net20  r=18
r1546 xxdec|xn3|mm2|drn 1326:xxdec|net20  r=18
r1545 xxdec|xn3|mm2|drn 1325:xxdec|net20  r=18
r1544 xxdec|xn3|mm2|drn 1324:xxdec|net20  r=18
r1543 xxdec|xn3|mm2|drn 1323:xxdec|net20  r=18
r1542 xxdec|xn3|mm2|drn xxdec|xn3|mm3|drn  r=0.001
r1541 xxdec|xn3|mm1|drn 1322:xxdec|net20  r=18
r1540 xxdec|xi4|mm1|gate 1321:xxdec|net20  r=12.95
r1539 xxdec|xi4|mm1|gate 1316:xxdec|net20  r=14.55
r1538 1315:xxdec|net20 1321:xxdec|net20  r=8.50001
r1537 1315:xxdec|net20 1320:xxdec|net20  r=18
r1536 xxdec|xi4|mm0|gate 1315:xxdec|net20  r=8.81251
r1535 1308:xxdec|net15 1314:xxdec|net15  r=0.098
r1534 1308:xxdec|net15 1309:xxdec|net15  r=0.098
r1533 1307:xxdec|net15 xxdec|net15  r=0.098
r1532 1307:xxdec|net15 1308:xxdec|net15  r=2
r1531 1304:xxdec|net15 1306:xxdec|net15  r=0.098
r1530 1304:xxdec|net15 1305:xxdec|net15  r=0.098
r1529 1303:xxdec|net15 1304:xxdec|net15  r=2
r1528 1300:xxdec|net15 1301:xxdec|net15  r=0.119
r1527 1299:xxdec|net15 1300:xxdec|net15  r=0.266
r1526 1298:xxdec|net15 1299:xxdec|net15  r=0.266
r1525 1297:xxdec|net15 1298:xxdec|net15  r=0.266
r1524 1296:xxdec|net15 1309:xxdec|net15  r=0.525
r1523 1296:xxdec|net15 1297:xxdec|net15  r=0.266
r1522 1295:xxdec|net15 1313:xxdec|net15  r=0.119
r1521 1295:xxdec|net15 1306:xxdec|net15  r=0.427
r1520 1293:xxdec|net15 1311:xxdec|net15  r=0.07
r1519 1293:xxdec|net15 1302:xxdec|net15  r=0.07
r1518 1291:xxdec|net15 1303:xxdec|net15  r=0.042
r1517 1291:xxdec|net15 1307:xxdec|net15  r=0.527333
r1516 1290:xxdec|net15 1293:xxdec|net15  r=2
r1515 1290:xxdec|net15 1303:xxdec|net15  r=0.445666
r1514 1290:xxdec|net15 1310:xxdec|net15  r=0.098
r1513 1290:xxdec|net15 1312:xxdec|net15  r=0.098
r1512 1290:xxdec|net15 1292:xxdec|net15  r=0.0629066
r1511 xxdec|xn2|mm2|drn 1296:xxdec|net15  r=18
r1510 xxdec|xn2|mm2|drn 1299:xxdec|net15  r=18
r1509 xxdec|xn2|mm2|drn 1297:xxdec|net15  r=18
r1508 xxdec|xn2|mm2|drn 1300:xxdec|net15  r=18
r1507 xxdec|xn2|mm2|drn 1298:xxdec|net15  r=18
r1506 xxdec|xn2|mm2|drn xxdec|xn2|mm3|drn  r=0.001
r1505 xxdec|xn2|mm1|drn 1295:xxdec|net15  r=18
r1504 xxdec|xi3|mm1|gate 1294:xxdec|net15  r=12.95
r1503 xxdec|xi3|mm1|gate 1289:xxdec|net15  r=14.55
r1502 1288:xxdec|net15 1294:xxdec|net15  r=8.50001
r1501 1288:xxdec|net15 1293:xxdec|net15  r=18
r1500 xxdec|xi3|mm0|gate 1288:xxdec|net15  r=8.81251
r1499 1281:xxdec|net10 1287:xxdec|net10  r=0.098
r1498 1281:xxdec|net10 1282:xxdec|net10  r=0.098
r1497 1280:xxdec|net10 xxdec|net10  r=0.098
r1496 1280:xxdec|net10 1281:xxdec|net10  r=2
r1495 1277:xxdec|net10 1279:xxdec|net10  r=0.098
r1494 1277:xxdec|net10 1278:xxdec|net10  r=0.098
r1493 1276:xxdec|net10 1277:xxdec|net10  r=2
r1492 1273:xxdec|net10 1274:xxdec|net10  r=0.119
r1491 1272:xxdec|net10 1273:xxdec|net10  r=0.266
r1490 1271:xxdec|net10 1272:xxdec|net10  r=0.266
r1489 1270:xxdec|net10 1271:xxdec|net10  r=0.266
r1488 1269:xxdec|net10 1282:xxdec|net10  r=0.525
r1487 1269:xxdec|net10 1270:xxdec|net10  r=0.266
r1486 1268:xxdec|net10 1286:xxdec|net10  r=0.119
r1485 1268:xxdec|net10 1279:xxdec|net10  r=0.427
r1484 1266:xxdec|net10 1284:xxdec|net10  r=0.07
r1483 1266:xxdec|net10 1275:xxdec|net10  r=0.07
r1482 1264:xxdec|net10 1276:xxdec|net10  r=0.042
r1481 1264:xxdec|net10 1280:xxdec|net10  r=0.527333
r1480 1263:xxdec|net10 1266:xxdec|net10  r=2
r1479 1263:xxdec|net10 1276:xxdec|net10  r=0.445666
r1478 1263:xxdec|net10 1283:xxdec|net10  r=0.098
r1477 1263:xxdec|net10 1285:xxdec|net10  r=0.098
r1476 1263:xxdec|net10 1265:xxdec|net10  r=0.0629066
r1475 xxdec|xn1|mm2|drn 1269:xxdec|net10  r=18
r1474 xxdec|xn1|mm2|drn 1272:xxdec|net10  r=18
r1473 xxdec|xn1|mm2|drn xxdec|xn1|mm3|drn  r=0.001
r1472 xxdec|xn1|mm2|drn 1270:xxdec|net10  r=18
r1471 xxdec|xn1|mm2|drn 1273:xxdec|net10  r=18
r1470 xxdec|xn1|mm2|drn 1271:xxdec|net10  r=18
r1469 xxdec|xn1|mm1|drn 1268:xxdec|net10  r=18
r1468 xxdec|xi2|mm1|gate 1267:xxdec|net10  r=12.95
r1467 xxdec|xi2|mm1|gate 1262:xxdec|net10  r=14.55
r1466 1261:xxdec|net10 1267:xxdec|net10  r=8.50001
r1465 1261:xxdec|net10 1266:xxdec|net10  r=18
r1464 xxdec|xi2|mm0|gate 1261:xxdec|net10  r=8.81251
r1463 1254:xxdec|net5 1260:xxdec|net5  r=0.098
r1462 1254:xxdec|net5 1255:xxdec|net5  r=0.098
r1461 1253:xxdec|net5 xxdec|net5  r=0.098
r1460 1253:xxdec|net5 1254:xxdec|net5  r=2
r1459 1250:xxdec|net5 1253:xxdec|net5  r=0.527333
r1458 1249:xxdec|net5 1252:xxdec|net5  r=0.098
r1457 1249:xxdec|net5 1251:xxdec|net5  r=0.098
r1456 1248:xxdec|net5 1250:xxdec|net5  r=0.042
r1455 1248:xxdec|net5 1249:xxdec|net5  r=2
r1454 1245:xxdec|net5 1246:xxdec|net5  r=0.119
r1453 1244:xxdec|net5 1245:xxdec|net5  r=0.266
r1452 1243:xxdec|net5 1244:xxdec|net5  r=0.266
r1451 1242:xxdec|net5 1243:xxdec|net5  r=0.266
r1450 1241:xxdec|net5 1255:xxdec|net5  r=0.525
r1449 1241:xxdec|net5 1242:xxdec|net5  r=0.266
r1448 1240:xxdec|net5 1259:xxdec|net5  r=0.119
r1447 1240:xxdec|net5 1252:xxdec|net5  r=0.427
r1446 1238:xxdec|net5 1257:xxdec|net5  r=0.07
r1445 1238:xxdec|net5 1247:xxdec|net5  r=0.07
r1444 1236:xxdec|net5 1238:xxdec|net5  r=2
r1443 1236:xxdec|net5 1248:xxdec|net5  r=0.445666
r1442 1236:xxdec|net5 1256:xxdec|net5  r=0.098
r1441 1236:xxdec|net5 1258:xxdec|net5  r=0.098
r1440 1236:xxdec|net5 1237:xxdec|net5  r=0.0629066
r1439 xxdec|xn0|mm2|drn 1241:xxdec|net5  r=18
r1438 xxdec|xn0|mm2|drn 1244:xxdec|net5  r=18
r1437 xxdec|xn0|mm2|drn 1242:xxdec|net5  r=18
r1436 xxdec|xn0|mm2|drn 1245:xxdec|net5  r=18
r1435 xxdec|xn0|mm2|drn xxdec|xn0|mm3|drn  r=0.001
r1434 xxdec|xn0|mm2|drn 1243:xxdec|net5  r=18
r1433 xxdec|xn0|mm1|drn 1240:xxdec|net5  r=18
r1432 xxdec|xi1|mm1|gate 1239:xxdec|net5  r=12.95
r1431 xxdec|xi1|mm1|gate 1235:xxdec|net5  r=14.55
r1430 1234:xxdec|net5 1239:xxdec|net5  r=8.50001
r1429 1234:xxdec|net5 1238:xxdec|net5  r=18
r1428 xxdec|xi1|mm0|gate 1234:xxdec|net5  r=8.81251
r1427 xxdec|ab 1226:xxdec|ab  r=3.346
r1426 1220:xxdec|ab xxdec|ab  r=0.266
r1425 1219:xxdec|ab 1220:xxdec|ab  r=0.266
r1424 1218:xxdec|ab 1219:xxdec|ab  r=0.266
r1423 1217:xxdec|ab 1218:xxdec|ab  r=0.266
r1422 1216:xxdec|ab 1232:xxdec|ab  r=0.119
r1421 1216:xxdec|ab 1217:xxdec|ab  r=1.246
r1420 1214:xxdec|ab 1233:xxdec|ab  r=0.119
r1419 1214:xxdec|ab 1224:xxdec|ab  r=5.005
r1418 1212:xxdec|ab 1231:xxdec|ab  r=0.119
r1417 1212:xxdec|ab 1222:xxdec|ab  r=5.005
r1416 1211:xxdec|ab 1226:xxdec|ab  r=0.05
r1415 1211:xxdec|ab 1225:xxdec|ab  r=0.06
r1414 1209:xxdec|ab 1224:xxdec|ab  r=0.05
r1413 1209:xxdec|ab 1223:xxdec|ab  r=0.06
r1412 1208:xxdec|ab 1230:xxdec|ab  r=0.098
r1411 1208:xxdec|ab 1227:xxdec|ab  r=0.049
r1410 1208:xxdec|ab 1211:xxdec|ab  r=2
r1409 1208:xxdec|ab 1210:xxdec|ab  r=0.0629066
r1408 1206:xxdec|ab 1222:xxdec|ab  r=0.05
r1407 1206:xxdec|ab 1221:xxdec|ab  r=0.06
r1406 1204:xxdec|ab 1229:xxdec|ab  r=0.098
r1405 1204:xxdec|ab 1209:xxdec|ab  r=2
r1404 1204:xxdec|ab 1208:xxdec|ab  r=0.730333
r1403 1204:xxdec|ab 1207:xxdec|ab  r=0.0629066
r1402 xxdec|xi0|mm1|drn xxdec|ab  r=18
r1401 xxdec|xi0|mm1|drn 1220:xxdec|ab  r=18
r1400 xxdec|xi0|mm1|drn 1219:xxdec|ab  r=18
r1399 xxdec|xi0|mm1|drn 1218:xxdec|ab  r=18
r1398 xxdec|xi0|mm1|drn 1217:xxdec|ab  r=18
r1397 xxdec|xi0|mm0|drn 1216:xxdec|ab  r=18
r1396 1202:xxdec|ab 1228:xxdec|ab  r=0.098
r1395 1202:xxdec|ab 1206:xxdec|ab  r=2
r1394 1202:xxdec|ab 1205:xxdec|ab  r=0.098
r1393 1202:xxdec|ab 1204:xxdec|ab  r=2.92133
r1392 1202:xxdec|ab 1203:xxdec|ab  r=0.0629066
r1391 xxdec|xn0|mm3|gate 1215:xxdec|ab  r=12.95
r1390 xxdec|xn0|mm3|gate 1201:xxdec|ab  r=14.55
r1389 1200:xxdec|ab 1215:xxdec|ab  r=7.12501
r1388 1200:xxdec|ab 1214:xxdec|ab  r=18
r1387 xxdec|xn0|mm1|gate 1200:xxdec|ab  r=10.1875
r1386 xxdec|xn2|mm3|gate 1213:xxdec|ab  r=12.95
r1385 xxdec|xn2|mm3|gate 1199:xxdec|ab  r=14.55
r1384 1198:xxdec|ab 1213:xxdec|ab  r=7.12501
r1383 1198:xxdec|ab 1212:xxdec|ab  r=18
r1382 xxdec|xn2|mm1|gate 1198:xxdec|ab  r=10.1875
r1381 1186:xxarr|xi3|qb 1195:xxarr|xi3|qb  r=0.135333
r1380 1185:xxarr|xi3|qb 1192:xxarr|xi3|qb  r=0.098
r1379 1185:xxarr|xi3|qb 1189:xxarr|xi3|qb  r=0.098
r1378 1184:xxarr|xi3|qb 1186:xxarr|xi3|qb  r=0.401333
r1377 1184:xxarr|xi3|qb 1185:xxarr|xi3|qb  r=2
r1376 1182:xxarr|xi3|qb 1184:xxarr|xi3|qb  r=0.788666
r1375 1182:xxarr|xi3|qb 1183:xxarr|xi3|qb  r=0.098
r1374 1180:xxarr|xi3|qb 1192:xxarr|xi3|qb  r=0.42
r1373 1180:xxarr|xi3|qb 1181:xxarr|xi3|qb  r=0.119
r1372 1179:xxarr|xi3|qb 1197:xxarr|xi3|qb  r=0.119
r1371 1179:xxarr|xi3|qb 1189:xxarr|xi3|qb  r=1.54
r1370 1177:xxarr|xi3|qb 1187:xxarr|xi3|qb  r=4.3125
r1369 1177:xxarr|xi3|qb 1178:xxarr|xi3|qb  r=4.3125
r1368 1176:xxarr|xi3|qb 1196:xxarr|xi3|qb  r=0.05005
r1367 1176:xxarr|xi3|qb 1191:xxarr|xi3|qb  r=0.05005
r1366 1176:xxarr|xi3|qb 1186:xxarr|xi3|qb  r=2
r1365 1176:xxarr|xi3|qb 1177:xxarr|xi3|qb  r=18
r1364 1173:xxarr|xi3|qb 1175:xxarr|xi3|qb  r=5.44737
r1363 1173:xxarr|xi3|qb 1174:xxarr|xi3|qb  r=5.44737
r1362 1172:xxarr|xi3|qb 1194:xxarr|xi3|qb  r=0.05005
r1361 1172:xxarr|xi3|qb 1193:xxarr|xi3|qb  r=0.05005
r1360 1172:xxarr|xi3|qb 1182:xxarr|xi3|qb  r=2
r1359 1172:xxarr|xi3|qb 1173:xxarr|xi3|qb  r=18
r1358 1171:xxarr|xi3|qb 1187:xxarr|xi3|qb  r=17.1
r1357 1170:xxarr|xi3|qb 1179:xxarr|xi3|qb  r=18
r1356 1170:xxarr|xi3|qb xxarr|xi3|mpd2|drn  r=7.5
r1355 xxarr|xi3|mpg2|drn 1170:xxarr|xi3|qb  r=7.5
r1354 1169:xxarr|xi3|qb xxarr|xi3|qb  r=11.7
r1353 xxarr|xi3|mpu1|gate 1171:xxarr|xi3|qb  r=9.00001
r1352 xxarr|xi3|mpu1|gate 1169:xxarr|xi3|qb  r=9.00001
r1351 1168:xxarr|xi3|qb 1178:xxarr|xi3|qb  r=89.1001
r1350 1167:xxarr|xi3|qb 1190:xxarr|xi3|qb  r=11.7
r1349 xxarr|xi3|mpd1|gate 1168:xxarr|xi3|qb  r=9.00001
r1348 xxarr|xi3|mpd1|gate 1167:xxarr|xi3|qb  r=9.00001
r1347 1166:xxarr|xi3|qb 1175:xxarr|xi3|qb  r=89.1001
r1346 1165:xxarr|xi3|qb 1188:xxarr|xi3|qb  r=11.7
r1345 xxarr|xi3|mra1|gate 1166:xxarr|xi3|qb  r=9.00001
r1344 xxarr|xi3|mra1|gate 1165:xxarr|xi3|qb  r=9.00001
r1343 1164:xxarr|xi3|qb xxarr|xi3|mpu2|drn  r=13.2
r1342 1163:xxarr|xi3|qb 1180:xxarr|xi3|qb  r=18
r1341 1163:xxarr|xi3|qb xxarr|xi3|mpu2|drn  r=7.5
r1340 1163:xxarr|xi3|qb 1164:xxarr|xi3|qb  r=5.7
r1339 1155:xxarr|xi3|q 1159:xxarr|xi3|q  r=0.098
r1338 1155:xxarr|xi3|q 1158:xxarr|xi3|q  r=0.098
r1337 1154:xxarr|xi3|q 1160:xxarr|xi3|q  r=0.098
r1336 1154:xxarr|xi3|q 1155:xxarr|xi3|q  r=2
r1335 1151:xxarr|xi3|q 1154:xxarr|xi3|q  r=0.443333
r1334 1151:xxarr|xi3|q 1153:xxarr|xi3|q  r=0.098
r1333 1149:xxarr|xi3|q 1159:xxarr|xi3|q  r=1.26
r1332 1149:xxarr|xi3|q 1150:xxarr|xi3|q  r=0.119
r1331 1148:xxarr|xi3|q 1162:xxarr|xi3|q  r=0.119
r1330 1148:xxarr|xi3|q 1158:xxarr|xi3|q  r=0.7
r1329 1146:xxarr|xi3|q 1156:xxarr|xi3|q  r=5.3077
r1328 1146:xxarr|xi3|q 1147:xxarr|xi3|q  r=5.3077
r1327 1145:xxarr|xi3|q 1161:xxarr|xi3|q  r=0.130667
r1326 1145:xxarr|xi3|q 1152:xxarr|xi3|q  r=0.130667
r1325 1145:xxarr|xi3|q 1151:xxarr|xi3|q  r=2
r1324 1145:xxarr|xi3|q 1146:xxarr|xi3|q  r=18
r1323 1144:xxarr|xi3|q 1156:xxarr|xi3|q  r=71.1001
r1322 1143:xxarr|xi3|q 1148:xxarr|xi3|q  r=18
r1321 1143:xxarr|xi3|q xxarr|xi3|mpg1|src  r=7.5
r1320 xxarr|xi3|mpd1|drn 1143:xxarr|xi3|q  r=7.5
r1319 1142:xxarr|xi3|q xxarr|xi3|q  r=11.7
r1318 xxarr|xi3|mpu2|gate 1144:xxarr|xi3|q  r=9.00001
r1317 xxarr|xi3|mpu2|gate 1142:xxarr|xi3|q  r=9.00001
r1316 1141:xxarr|xi3|q 1147:xxarr|xi3|q  r=35.1
r1315 1140:xxarr|xi3|q 1157:xxarr|xi3|q  r=11.7
r1314 xxarr|xi3|mpd2|gate 1141:xxarr|xi3|q  r=9.00001
r1313 xxarr|xi3|mpd2|gate 1140:xxarr|xi3|q  r=9.00001
r1312 1139:xxarr|xi3|q 1149:xxarr|xi3|q  r=18
r1311 1139:xxarr|xi3|q xxarr|xi3|mpu1|drn  r=7.5
r1310 1138:xxarr|xi3|q xxarr|xi3|mpu1|drn  r=13.2
r1309 1138:xxarr|xi3|q 1139:xxarr|xi3|q  r=5.7
r1308 1136:ln_xarr|x_r1c1|n_63 1137:ln_xarr|x_r1c1|n_63  r=10.8947
r1307 1135:ln_xarr|x_r1c1|n_63 ln_xarr|x_r1c1|n_63  r=53.5501
r1306 1133:ln_xarr|x_r1c1|n_63 1135:ln_xarr|x_r1c1|n_63  r=104
r1305 1133:ln_xarr|x_r1c1|n_63 1136:ln_xarr|x_r1c1|n_63  r=29
r1304 1133:ln_xarr|x_r1c1|n_63 1134:ln_xarr|x_r1c1|n_63  r=53.5501
r1303 1131:ln_xarr|x_r0c1|n_65 ln_xarr|x_r0c1|n_65  r=41.4
r1302 1130:ln_xarr|x_r0c1|n_65 1131:ln_xarr|x_r0c1|n_65  r=57.5527
r1301 1130:ln_xarr|x_r0c1|n_65 1132:ln_xarr|x_r0c1|n_65  r=5.37288
r1300 1127:ln_xarr|x_r1c1|n_65 1129:ln_xarr|x_r1c1|n_65  r=41.4
r1299 1126:ln_xarr|x_r1c1|n_65 1128:ln_xarr|x_r1c1|n_65  r=5.37288
r1298 ln_xarr|x_r1c1|n_65 1126:ln_xarr|x_r1c1|n_65  r=57.5527
r1297 ln_xarr|x_r1c1|n_65 1127:ln_xarr|x_r1c1|n_65  r=0.001
r1296 1124:ln_xarr|x_r0c1|n_63 1125:ln_xarr|x_r0c1|n_63  r=10.8947
r1295 1123:ln_xarr|x_r0c1|n_63 ln_xarr|x_r0c1|n_63  r=53.5501
r1294 1121:ln_xarr|x_r0c1|n_63 1124:ln_xarr|x_r0c1|n_63  r=29
r1293 1121:ln_xarr|x_r0c1|n_63 1122:ln_xarr|x_r0c1|n_63  r=53.5501
r1292 1121:ln_xarr|x_r0c1|n_63 1123:ln_xarr|x_r0c1|n_63  r=104
r1291 1119:xxarr|xi3|net5 1120:xxarr|xi3|net5  r=0.0665
r1290 1119:xxarr|xi3|net5 xxarr|xi3|net5  r=0.0735
r1289 1118:xxarr|xi3|net5 1119:xxarr|xi3|net5  r=18
r1288 1118:xxarr|xi3|net5 xxarr|xi3|mra1|drn  r=7.5
r1287 xxarr|xi3|mra2|src 1118:xxarr|xi3|net5  r=7.5
r1286 1106:xxarr|xi2|qb 1115:xxarr|xi2|qb  r=0.135333
r1285 1105:xxarr|xi2|qb 1111:xxarr|xi2|qb  r=0.098
r1284 1105:xxarr|xi2|qb 1110:xxarr|xi2|qb  r=0.098
r1283 1104:xxarr|xi2|qb 1106:xxarr|xi2|qb  r=0.401333
r1282 1104:xxarr|xi2|qb 1105:xxarr|xi2|qb  r=2
r1281 1102:xxarr|xi2|qb 1104:xxarr|xi2|qb  r=0.788666
r1280 1102:xxarr|xi2|qb 1103:xxarr|xi2|qb  r=0.098
r1279 1100:xxarr|xi2|qb 1110:xxarr|xi2|qb  r=0.42
r1278 1100:xxarr|xi2|qb 1101:xxarr|xi2|qb  r=0.119
r1277 1099:xxarr|xi2|qb 1117:xxarr|xi2|qb  r=0.119
r1276 1099:xxarr|xi2|qb 1111:xxarr|xi2|qb  r=1.54
r1275 1097:xxarr|xi2|qb 1107:xxarr|xi2|qb  r=4.3125
r1274 1097:xxarr|xi2|qb 1098:xxarr|xi2|qb  r=4.3125
r1273 1096:xxarr|xi2|qb 1114:xxarr|xi2|qb  r=0.05005
r1272 1096:xxarr|xi2|qb 1113:xxarr|xi2|qb  r=0.05005
r1271 1096:xxarr|xi2|qb 1106:xxarr|xi2|qb  r=2
r1270 1096:xxarr|xi2|qb 1097:xxarr|xi2|qb  r=18
r1269 1093:xxarr|xi2|qb 1095:xxarr|xi2|qb  r=5.44737
r1268 1093:xxarr|xi2|qb 1094:xxarr|xi2|qb  r=5.44737
r1267 1092:xxarr|xi2|qb 1116:xxarr|xi2|qb  r=0.05005
r1266 1092:xxarr|xi2|qb 1109:xxarr|xi2|qb  r=0.05005
r1265 1092:xxarr|xi2|qb 1102:xxarr|xi2|qb  r=2
r1264 1092:xxarr|xi2|qb 1093:xxarr|xi2|qb  r=18
r1263 1091:xxarr|xi2|qb 1107:xxarr|xi2|qb  r=17.1
r1262 1090:xxarr|xi2|qb 1099:xxarr|xi2|qb  r=18
r1261 1090:xxarr|xi2|qb xxarr|xi2|mpd2|drn  r=7.5
r1260 xxarr|xi2|mpg2|drn 1090:xxarr|xi2|qb  r=7.5
r1259 1089:xxarr|xi2|qb xxarr|xi2|qb  r=11.7
r1258 xxarr|xi2|mpu1|gate 1091:xxarr|xi2|qb  r=9.00001
r1257 xxarr|xi2|mpu1|gate 1089:xxarr|xi2|qb  r=9.00001
r1256 1088:xxarr|xi2|qb 1098:xxarr|xi2|qb  r=89.1001
r1255 1087:xxarr|xi2|qb 1112:xxarr|xi2|qb  r=11.7
r1254 xxarr|xi2|mpd1|gate 1088:xxarr|xi2|qb  r=9.00001
r1253 xxarr|xi2|mpd1|gate 1087:xxarr|xi2|qb  r=9.00001
r1252 1086:xxarr|xi2|qb 1095:xxarr|xi2|qb  r=89.1001
r1251 1085:xxarr|xi2|qb 1108:xxarr|xi2|qb  r=11.7
r1250 xxarr|xi2|mra1|gate 1086:xxarr|xi2|qb  r=9.00001
r1249 xxarr|xi2|mra1|gate 1085:xxarr|xi2|qb  r=9.00001
r1248 1084:xxarr|xi2|qb xxarr|xi2|mpu2|drn  r=13.2
r1247 1083:xxarr|xi2|qb 1100:xxarr|xi2|qb  r=18
r1246 1083:xxarr|xi2|qb xxarr|xi2|mpu2|drn  r=7.5
r1245 1083:xxarr|xi2|qb 1084:xxarr|xi2|qb  r=5.7
r1244 1075:xxarr|xi2|q 1079:xxarr|xi2|q  r=0.098
r1243 1075:xxarr|xi2|q 1078:xxarr|xi2|q  r=0.098
r1242 1074:xxarr|xi2|q 1080:xxarr|xi2|q  r=0.098
r1241 1074:xxarr|xi2|q 1075:xxarr|xi2|q  r=2
r1240 1071:xxarr|xi2|q 1074:xxarr|xi2|q  r=0.443333
r1239 1071:xxarr|xi2|q 1073:xxarr|xi2|q  r=0.098
r1238 1069:xxarr|xi2|q 1079:xxarr|xi2|q  r=1.26
r1237 1069:xxarr|xi2|q 1070:xxarr|xi2|q  r=0.119
r1236 1068:xxarr|xi2|q 1081:xxarr|xi2|q  r=0.119
r1235 1068:xxarr|xi2|q 1078:xxarr|xi2|q  r=0.7
r1234 1066:xxarr|xi2|q 1076:xxarr|xi2|q  r=5.3077
r1233 1066:xxarr|xi2|q 1067:xxarr|xi2|q  r=5.3077
r1232 1065:xxarr|xi2|q 1082:xxarr|xi2|q  r=0.130667
r1231 1065:xxarr|xi2|q 1072:xxarr|xi2|q  r=0.130667
r1230 1065:xxarr|xi2|q 1071:xxarr|xi2|q  r=2
r1229 1065:xxarr|xi2|q 1066:xxarr|xi2|q  r=18
r1228 1064:xxarr|xi2|q 1076:xxarr|xi2|q  r=71.1001
r1227 1063:xxarr|xi2|q 1068:xxarr|xi2|q  r=18
r1226 1063:xxarr|xi2|q xxarr|xi2|mpg1|src  r=7.5
r1225 xxarr|xi2|mpd1|drn 1063:xxarr|xi2|q  r=7.5
r1224 1062:xxarr|xi2|q xxarr|xi2|q  r=11.7
r1223 xxarr|xi2|mpu2|gate 1064:xxarr|xi2|q  r=9.00001
r1222 xxarr|xi2|mpu2|gate 1062:xxarr|xi2|q  r=9.00001
r1221 1061:xxarr|xi2|q 1067:xxarr|xi2|q  r=35.1
r1220 1060:xxarr|xi2|q 1077:xxarr|xi2|q  r=11.7
r1219 xxarr|xi2|mpd2|gate 1061:xxarr|xi2|q  r=9.00001
r1218 xxarr|xi2|mpd2|gate 1060:xxarr|xi2|q  r=9.00001
r1217 1059:xxarr|xi2|q 1069:xxarr|xi2|q  r=18
r1216 1059:xxarr|xi2|q xxarr|xi2|mpu1|drn  r=7.5
r1215 1058:xxarr|xi2|q xxarr|xi2|mpu1|drn  r=13.2
r1214 1058:xxarr|xi2|q 1059:xxarr|xi2|q  r=5.7
r1213 1056:ln_xarr|x_r1c0|n_63 1057:ln_xarr|x_r1c0|n_63  r=10.8947
r1212 1055:ln_xarr|x_r1c0|n_63 ln_xarr|x_r1c0|n_63  r=53.5501
r1211 1053:ln_xarr|x_r1c0|n_63 1054:ln_xarr|x_r1c0|n_63  r=53.5501
r1210 1053:ln_xarr|x_r1c0|n_63 1056:ln_xarr|x_r1c0|n_63  r=29
r1209 1053:ln_xarr|x_r1c0|n_63 1055:ln_xarr|x_r1c0|n_63  r=104
r1208 1051:ln_xarr|x_r0c0|n_65 ln_xarr|x_r0c0|n_65  r=41.4
r1207 1050:ln_xarr|x_r0c0|n_65 1051:ln_xarr|x_r0c0|n_65  r=57.5527
r1206 1050:ln_xarr|x_r0c0|n_65 1052:ln_xarr|x_r0c0|n_65  r=5.37288
r1205 1048:ln_xarr|x_r0c0|n_63 1049:ln_xarr|x_r0c0|n_63  r=10.8947
r1204 1047:ln_xarr|x_r0c0|n_63 ln_xarr|x_r0c0|n_63  r=53.5501
r1203 1045:ln_xarr|x_r0c0|n_63 1048:ln_xarr|x_r0c0|n_63  r=29
r1202 1045:ln_xarr|x_r0c0|n_63 1046:ln_xarr|x_r0c0|n_63  r=53.5501
r1201 1045:ln_xarr|x_r0c0|n_63 1047:ln_xarr|x_r0c0|n_63  r=104
r1200 1043:xxarr|xi2|net5 1044:xxarr|xi2|net5  r=0.0665
r1199 1043:xxarr|xi2|net5 xxarr|xi2|net5  r=0.0735
r1198 1042:xxarr|xi2|net5 1043:xxarr|xi2|net5  r=18
r1197 1042:xxarr|xi2|net5 xxarr|xi2|mra1|drn  r=7.5
r1196 xxarr|xi2|mra2|src 1042:xxarr|xi2|net5  r=7.5
r1195 1030:xxarr|xi1|qb 1031:xxarr|xi1|qb  r=89.1001
r1194 1029:xxarr|xi1|qb 1036:xxarr|xi1|qb  r=0.135333
r1193 1028:xxarr|xi1|qb 1038:xxarr|xi1|qb  r=0.098
r1192 1028:xxarr|xi1|qb 1035:xxarr|xi1|qb  r=0.098
r1191 1027:xxarr|xi1|qb 1029:xxarr|xi1|qb  r=0.401333
r1190 1027:xxarr|xi1|qb 1028:xxarr|xi1|qb  r=2
r1189 1025:xxarr|xi1|qb 1027:xxarr|xi1|qb  r=0.788666
r1188 1025:xxarr|xi1|qb 1026:xxarr|xi1|qb  r=0.098
r1187 1023:xxarr|xi1|qb 1035:xxarr|xi1|qb  r=1.54
r1186 1023:xxarr|xi1|qb 1024:xxarr|xi1|qb  r=0.119
r1185 1022:xxarr|xi1|qb 1040:xxarr|xi1|qb  r=0.119
r1184 1022:xxarr|xi1|qb 1038:xxarr|xi1|qb  r=0.42
r1183 1020:xxarr|xi1|qb 1031:xxarr|xi1|qb  r=4.3125
r1182 1020:xxarr|xi1|qb 1021:xxarr|xi1|qb  r=4.3125
r1181 1019:xxarr|xi1|qb 1041:xxarr|xi1|qb  r=0.05005
r1180 1019:xxarr|xi1|qb 1033:xxarr|xi1|qb  r=0.05005
r1179 1019:xxarr|xi1|qb 1029:xxarr|xi1|qb  r=2
r1178 1019:xxarr|xi1|qb 1020:xxarr|xi1|qb  r=18
r1177 1017:xxarr|xi1|qb 1032:xxarr|xi1|qb  r=5.44737
r1176 1017:xxarr|xi1|qb 1018:xxarr|xi1|qb  r=5.44737
r1175 1016:xxarr|xi1|qb 1039:xxarr|xi1|qb  r=0.05005
r1174 1016:xxarr|xi1|qb 1037:xxarr|xi1|qb  r=0.05005
r1173 1016:xxarr|xi1|qb 1025:xxarr|xi1|qb  r=2
r1172 1016:xxarr|xi1|qb 1017:xxarr|xi1|qb  r=18
r1171 1015:xxarr|xi1|qb 1021:xxarr|xi1|qb  r=17.1
r1170 1013:xxarr|xi1|qb 1023:xxarr|xi1|qb  r=18
r1169 1013:xxarr|xi1|qb xxarr|xi1|mpd2|drn  r=7.5
r1168 xxarr|xi1|mpg2|drn 1013:xxarr|xi1|qb  r=7.5
r1167 1012:xxarr|xi1|qb xxarr|xi1|qb  r=11.7
r1166 xxarr|xi1|mpd1|gate 1030:xxarr|xi1|qb  r=9.00001
r1165 xxarr|xi1|mpd1|gate 1012:xxarr|xi1|qb  r=9.00001
r1164 1011:xxarr|xi1|qb 1034:xxarr|xi1|qb  r=11.7
r1163 xxarr|xi1|mpu1|gate 1015:xxarr|xi1|qb  r=9.00001
r1162 xxarr|xi1|mpu1|gate 1011:xxarr|xi1|qb  r=9.00001
r1161 1010:xxarr|xi1|qb 1014:xxarr|xi1|qb  r=11.7
r1160 1009:xxarr|xi1|qb 1032:xxarr|xi1|qb  r=89.1001
r1159 xxarr|xi1|mra1|gate 1010:xxarr|xi1|qb  r=9.00001
r1158 xxarr|xi1|mra1|gate 1009:xxarr|xi1|qb  r=9.00001
r1157 1008:xxarr|xi1|qb xxarr|xi1|mpu2|drn  r=13.2
r1156 1007:xxarr|xi1|qb 1022:xxarr|xi1|qb  r=18
r1155 1007:xxarr|xi1|qb xxarr|xi1|mpu2|drn  r=7.5
r1154 1007:xxarr|xi1|qb 1008:xxarr|xi1|qb  r=5.7
r1153 999:xxarr|xi1|q 1000:xxarr|xi1|q  r=35.1
r1152 998:xxarr|xi1|q 1003:xxarr|xi1|q  r=0.098
r1151 998:xxarr|xi1|q 1002:xxarr|xi1|q  r=0.098
r1150 997:xxarr|xi1|q 1004:xxarr|xi1|q  r=0.098
r1149 997:xxarr|xi1|q 998:xxarr|xi1|q  r=2
r1148 994:xxarr|xi1|q 997:xxarr|xi1|q  r=0.443333
r1147 994:xxarr|xi1|q 996:xxarr|xi1|q  r=0.098
r1146 992:xxarr|xi1|q 1003:xxarr|xi1|q  r=0.7
r1145 992:xxarr|xi1|q 993:xxarr|xi1|q  r=0.119
r1144 991:xxarr|xi1|q 1006:xxarr|xi1|q  r=0.119
r1143 991:xxarr|xi1|q 1002:xxarr|xi1|q  r=1.26
r1142 989:xxarr|xi1|q 1000:xxarr|xi1|q  r=5.3077
r1141 989:xxarr|xi1|q 990:xxarr|xi1|q  r=5.3077
r1140 988:xxarr|xi1|q 1005:xxarr|xi1|q  r=0.130667
r1139 988:xxarr|xi1|q 995:xxarr|xi1|q  r=0.130667
r1138 988:xxarr|xi1|q 994:xxarr|xi1|q  r=2
r1137 988:xxarr|xi1|q 989:xxarr|xi1|q  r=18
r1136 987:xxarr|xi1|q 992:xxarr|xi1|q  r=18
r1135 987:xxarr|xi1|q xxarr|xi1|mpg1|src  r=7.5
r1134 xxarr|xi1|mpd1|drn 987:xxarr|xi1|q  r=7.5
r1133 986:xxarr|xi1|q xxarr|xi1|q  r=11.7
r1132 xxarr|xi1|mpd2|gate 999:xxarr|xi1|q  r=9.00001
r1131 xxarr|xi1|mpd2|gate 986:xxarr|xi1|q  r=9.00001
r1130 985:xxarr|xi1|q 990:xxarr|xi1|q  r=71.1001
r1129 984:xxarr|xi1|q 1001:xxarr|xi1|q  r=11.7
r1128 xxarr|xi1|mpu2|gate 985:xxarr|xi1|q  r=9.00001
r1127 xxarr|xi1|mpu2|gate 984:xxarr|xi1|q  r=9.00001
r1126 983:xxarr|xi1|q 991:xxarr|xi1|q  r=18
r1125 983:xxarr|xi1|q xxarr|xi1|mpu1|drn  r=7.5
r1124 982:xxarr|xi1|q xxarr|xi1|mpu1|drn  r=13.2
r1123 982:xxarr|xi1|q 983:xxarr|xi1|q  r=5.7
r1122 979:ln_xarr|x_r1c1|n_61 ln_xarr|x_r1c1|n_61  r=51.3001
r1121 979:ln_xarr|x_r1c1|n_61 981:ln_xarr|x_r1c1|n_61  r=123.3
r1120 979:ln_xarr|x_r1c1|n_61 980:ln_xarr|x_r1c1|n_61  r=7.43479
r1119 977:xxarr|xi1|net5 978:xxarr|xi1|net5  r=0.0665
r1118 977:xxarr|xi1|net5 xxarr|xi1|net5  r=0.0735
r1117 976:xxarr|xi1|net5 977:xxarr|xi1|net5  r=18
r1116 976:xxarr|xi1|net5 xxarr|xi1|mra1|drn  r=7.5
r1115 xxarr|xi1|mra2|src 976:xxarr|xi1|net5  r=7.5
r1114 964:xxarr|xi0|qb 965:xxarr|xi0|qb  r=89.1001
r1113 963:xxarr|xi0|qb 972:xxarr|xi0|qb  r=0.135333
r1112 962:xxarr|xi0|qb 971:xxarr|xi0|qb  r=0.098
r1111 962:xxarr|xi0|qb 969:xxarr|xi0|qb  r=0.098
r1110 961:xxarr|xi0|qb 963:xxarr|xi0|qb  r=0.401333
r1109 961:xxarr|xi0|qb 962:xxarr|xi0|qb  r=2
r1108 959:xxarr|xi0|qb 961:xxarr|xi0|qb  r=0.788666
r1107 959:xxarr|xi0|qb 960:xxarr|xi0|qb  r=0.098
r1106 957:xxarr|xi0|qb 969:xxarr|xi0|qb  r=1.54
r1105 957:xxarr|xi0|qb 958:xxarr|xi0|qb  r=0.119
r1104 956:xxarr|xi0|qb 974:xxarr|xi0|qb  r=0.119
r1103 956:xxarr|xi0|qb 971:xxarr|xi0|qb  r=0.42
r1102 954:xxarr|xi0|qb 965:xxarr|xi0|qb  r=4.3125
r1101 954:xxarr|xi0|qb 955:xxarr|xi0|qb  r=4.3125
r1100 953:xxarr|xi0|qb 975:xxarr|xi0|qb  r=0.05005
r1099 953:xxarr|xi0|qb 967:xxarr|xi0|qb  r=0.05005
r1098 953:xxarr|xi0|qb 963:xxarr|xi0|qb  r=2
r1097 953:xxarr|xi0|qb 954:xxarr|xi0|qb  r=18
r1096 951:xxarr|xi0|qb 966:xxarr|xi0|qb  r=5.44737
r1095 951:xxarr|xi0|qb 952:xxarr|xi0|qb  r=5.44737
r1094 950:xxarr|xi0|qb 973:xxarr|xi0|qb  r=0.05005
r1093 950:xxarr|xi0|qb 970:xxarr|xi0|qb  r=0.05005
r1092 950:xxarr|xi0|qb 959:xxarr|xi0|qb  r=2
r1091 950:xxarr|xi0|qb 951:xxarr|xi0|qb  r=18
r1090 949:xxarr|xi0|qb 955:xxarr|xi0|qb  r=17.1
r1089 947:xxarr|xi0|qb 957:xxarr|xi0|qb  r=18
r1088 947:xxarr|xi0|qb xxarr|xi0|mpd2|drn  r=7.5
r1087 xxarr|xi0|mpg2|drn 947:xxarr|xi0|qb  r=7.5
r1086 946:xxarr|xi0|qb xxarr|xi0|qb  r=11.7
r1085 xxarr|xi0|mpd1|gate 964:xxarr|xi0|qb  r=9.00001
r1084 xxarr|xi0|mpd1|gate 946:xxarr|xi0|qb  r=9.00001
r1083 945:xxarr|xi0|qb 968:xxarr|xi0|qb  r=11.7
r1082 xxarr|xi0|mpu1|gate 949:xxarr|xi0|qb  r=9.00001
r1081 xxarr|xi0|mpu1|gate 945:xxarr|xi0|qb  r=9.00001
r1080 944:xxarr|xi0|qb 948:xxarr|xi0|qb  r=11.7
r1079 943:xxarr|xi0|qb 966:xxarr|xi0|qb  r=89.1001
r1078 xxarr|xi0|mra1|gate 944:xxarr|xi0|qb  r=9.00001
r1077 xxarr|xi0|mra1|gate 943:xxarr|xi0|qb  r=9.00001
r1076 942:xxarr|xi0|qb xxarr|xi0|mpu2|drn  r=13.2
r1075 941:xxarr|xi0|qb 956:xxarr|xi0|qb  r=18
r1074 941:xxarr|xi0|qb xxarr|xi0|mpu2|drn  r=7.5
r1073 941:xxarr|xi0|qb 942:xxarr|xi0|qb  r=5.7
r1072 933:xxarr|xi0|q 934:xxarr|xi0|q  r=35.1
r1071 932:xxarr|xi0|q 937:xxarr|xi0|q  r=0.098
r1070 932:xxarr|xi0|q 936:xxarr|xi0|q  r=0.098
r1069 931:xxarr|xi0|q 938:xxarr|xi0|q  r=0.098
r1068 931:xxarr|xi0|q 932:xxarr|xi0|q  r=2
r1067 928:xxarr|xi0|q 931:xxarr|xi0|q  r=0.443333
r1066 928:xxarr|xi0|q 930:xxarr|xi0|q  r=0.098
r1065 926:xxarr|xi0|q 936:xxarr|xi0|q  r=0.7
r1064 926:xxarr|xi0|q 927:xxarr|xi0|q  r=0.119
r1063 925:xxarr|xi0|q 940:xxarr|xi0|q  r=0.119
r1062 925:xxarr|xi0|q 937:xxarr|xi0|q  r=1.26
r1061 923:xxarr|xi0|q 934:xxarr|xi0|q  r=5.3077
r1060 923:xxarr|xi0|q 924:xxarr|xi0|q  r=5.3077
r1059 922:xxarr|xi0|q 939:xxarr|xi0|q  r=0.130667
r1058 922:xxarr|xi0|q 929:xxarr|xi0|q  r=0.130667
r1057 922:xxarr|xi0|q 928:xxarr|xi0|q  r=2
r1056 922:xxarr|xi0|q 923:xxarr|xi0|q  r=18
r1055 921:xxarr|xi0|q 926:xxarr|xi0|q  r=18
r1054 921:xxarr|xi0|q xxarr|xi0|mpg1|src  r=7.5
r1053 xxarr|xi0|mpd1|drn 921:xxarr|xi0|q  r=7.5
r1052 920:xxarr|xi0|q xxarr|xi0|q  r=11.7
r1051 xxarr|xi0|mpd2|gate 933:xxarr|xi0|q  r=9.00001
r1050 xxarr|xi0|mpd2|gate 920:xxarr|xi0|q  r=9.00001
r1049 919:xxarr|xi0|q 924:xxarr|xi0|q  r=71.1001
r1048 918:xxarr|xi0|q 935:xxarr|xi0|q  r=11.7
r1047 xxarr|xi0|mpu2|gate 919:xxarr|xi0|q  r=9.00001
r1046 xxarr|xi0|mpu2|gate 918:xxarr|xi0|q  r=9.00001
r1045 917:xxarr|xi0|q 925:xxarr|xi0|q  r=18
r1044 917:xxarr|xi0|q xxarr|xi0|mpu1|drn  r=7.5
r1043 916:xxarr|xi0|q xxarr|xi0|mpu1|drn  r=13.2
r1042 916:xxarr|xi0|q 917:xxarr|xi0|q  r=5.7
r1041 913:ln_xarr|x_r0c1|n_61 ln_xarr|x_r0c1|n_61  r=123.3
r1040 913:ln_xarr|x_r0c1|n_61 914:ln_xarr|x_r0c1|n_61  r=51.3001
r1039 913:ln_xarr|x_r0c1|n_61 915:ln_xarr|x_r0c1|n_61  r=7.43479
r1038 899:rwl0 909:rwl0  r=0.098
r1037 899:rwl0 901:rwl0  r=0.098
r1036 899:rwl0 900:rwl0  r=0.098
r1035 894:rwl0 908:rwl0  r=0.424666
r1034 892:rwl0 893:rwl0  r=0.119
r1033 891:rwl0 892:rwl0  r=0.266
r1032 890:rwl0 891:rwl0  r=0.266
r1031 889:rwl0 890:rwl0  r=0.266
r1030 888:rwl0 889:rwl0  r=0.266
r1029 887:rwl0 907:rwl0  r=2.779
r1028 887:rwl0 888:rwl0  r=1.246
r1027 885:rwl0 912:rwl0  r=0.130667
r1026 885:rwl0 897:rwl0  r=0.130667
r1025 885:rwl0 896:rwl0  r=2
r1024 883:rwl0 911:rwl0  r=0.130667
r1023 883:rwl0 895:rwl0  r=0.130667
r1022 883:rwl0 894:rwl0  r=2
r1021 882:rwl0 906:rwl0  r=0.0514
r1020 882:rwl0 899:rwl0  r=2
r1019 881:rwl0 907:rwl0  r=0.05
r1018 881:rwl0 898:rwl0  r=0.0514
r1017 880:rwl0 881:rwl0  r=5.831
r1016 880:rwl0 882:rwl0  r=0.05
r1015 878:rwl0 910:rwl0  r=0.098
r1014 878:rwl0 905:rwl0  r=0.049
r1013 878:rwl0 881:rwl0  r=2
r1012 878:rwl0 879:rwl0  r=0.0629066
r1011 877:rwl0 878:rwl0  r=3.22467
r1010 876:rwl0 896:rwl0  r=2.31
r1009 876:rwl0 899:rwl0  r=2.06733
r1008 875:rwl0 903:rwl0  r=11.7
r1007 874:rwl0 902:rwl0  r=11.7
r1006 xxdec|xi3|mm1|drn 892:rwl0  r=18
r1005 xxdec|xi3|mm1|drn 891:rwl0  r=18
r1004 xxdec|xi3|mm1|drn 890:rwl0  r=18
r1003 xxdec|xi3|mm1|drn 889:rwl0  r=18
r1002 xxdec|xi3|mm1|drn 888:rwl0  r=18
r1001 xxdec|xi3|mm0|drn 887:rwl0  r=18
r1000 873:rwl0 rwl0  r=11.7
r999 xxarr|xi0|mra2|gate 875:rwl0  r=9.00001
r998 xxarr|xi0|mra2|gate 873:rwl0  r=9.00001
r997 872:rwl0 904:rwl0  r=11.7
r996 xxarr|xi1|mra2|gate 874:rwl0  r=9.00001
r995 xxarr|xi1|mra2|gate 872:rwl0  r=9.00001
r994 871:rwl0 903:rwl0  r=57.5527
r993 870:rwl0 886:rwl0  r=3.7174
r992 870:rwl0 885:rwl0  r=18
r991 870:rwl0 871:rwl0  r=1.07197
r990 869:rwl0 902:rwl0  r=57.5527
r989 868:rwl0 884:rwl0  r=3.7174
r988 868:rwl0 883:rwl0  r=18
r987 868:rwl0 869:rwl0  r=1.07197
r986 867:rwl0 896:rwl0  r=0.424666
r985 867:rwl0 894:rwl0  r=2.40333
r984 864:ln_xarr|x_r0c0|n_61 ln_xarr|x_r0c0|n_61  r=123.3
r983 864:ln_xarr|x_r0c0|n_61 865:ln_xarr|x_r0c0|n_61  r=51.3001
r982 864:ln_xarr|x_r0c0|n_61 866:ln_xarr|x_r0c0|n_61  r=7.43479
r981 862:xxarr|xi0|net5 863:xxarr|xi0|net5  r=0.0665
r980 862:xxarr|xi0|net5 xxarr|xi0|net5  r=0.0735
r979 861:xxarr|xi0|net5 862:xxarr|xi0|net5  r=18
r978 861:xxarr|xi0|net5 xxarr|xi0|mra1|drn  r=7.5
r977 xxarr|xi0|mra2|src 861:xxarr|xi0|net5  r=7.5
r976 wbl0 860:wbl0  r=0.0514
r975 wbl0 854:wbl0  r=0.05
r974 850:wbl0 853:wbl0  r=0.098
r973 850:wbl0 852:wbl0  r=0.098
r972 850:wbl0 851:wbl0  r=0.098
r971 850:wbl0 wbl0  r=2
r970 848:wbl0 857:wbl0  r=0.0514
r969 848:wbl0 856:wbl0  r=0.05
r968 847:wbl0 858:wbl0  r=0.252
r967 847:wbl0 848:wbl0  r=2
r966 847:wbl0 849:wbl0  r=0.098
r965 847:wbl0 855:wbl0  r=0.098
r964 847:wbl0 850:wbl0  r=0.495786
r963 846:wbl0 854:wbl0  r=0.994
r962 845:wbl0 859:wbl0  r=0.119
r961 845:wbl0 846:wbl0  r=5.53
r960 843:wbl0 844:wbl0  r=0.119
r959 843:wbl0 xxwd0|xi1|mm0|drn  r=18
r958 842:wbl0 843:wbl0  r=1.246
r957 841:wbl0 842:wbl0  r=0.266
r956 840:wbl0 841:wbl0  r=0.266
r955 839:wbl0 840:wbl0  r=0.266
r954 838:wbl0 856:wbl0  r=1.981
r953 838:wbl0 839:wbl0  r=0.266
r952 xxwd0|xi1|mm1|drn 842:wbl0  r=18
r951 xxwd0|xi1|mm1|drn 841:wbl0  r=18
r950 xxwd0|xi1|mm1|drn 840:wbl0  r=18
r949 xxwd0|xi1|mm1|drn 839:wbl0  r=18
r948 xxwd0|xi1|mm1|drn 838:wbl0  r=18
r947 837:wbl0 846:wbl0  r=18
r946 837:wbl0 xxarr|xi0|mpg1|drn  r=7.5
r945 836:wbl0 837:wbl0  r=5.7
r944 835:wbl0 845:wbl0  r=18
r943 835:wbl0 xxarr|xi2|mpg1|drn  r=7.5
r942 834:wbl0 835:wbl0  r=5.7
r941 817:wblb0 828:wblb0  r=0.098
r940 817:wblb0 827:wblb0  r=0.098
r939 817:wblb0 818:wblb0  r=0.098
r938 814:wblb0 831:wblb0  r=0.0514
r937 814:wblb0 824:wblb0  r=0.05
r936 813:wblb0 826:wblb0  r=0.098
r935 813:wblb0 816:wblb0  r=0.098
r934 813:wblb0 815:wblb0  r=0.098
r933 813:wblb0 814:wblb0  r=2
r932 811:wblb0 823:wblb0  r=0.05
r931 811:wblb0 822:wblb0  r=0.05
r930 810:wblb0 829:wblb0  r=0.098
r929 810:wblb0 820:wblb0  r=0.098
r928 810:wblb0 817:wblb0  r=1.61
r927 810:wblb0 812:wblb0  r=0.098
r926 810:wblb0 811:wblb0  r=2
r925 807:wblb0 825:wblb0  r=0.0514
r924 807:wblb0 808:wblb0  r=0.05
r923 806:wblb0 813:wblb0  r=0.514453
r922 806:wblb0 830:wblb0  r=0.252
r921 806:wblb0 809:wblb0  r=0.098
r920 806:wblb0 821:wblb0  r=0.098
r919 806:wblb0 807:wblb0  r=2
r918 805:wblb0 824:wblb0  r=0.994
r917 804:wblb0 832:wblb0  r=0.119
r916 804:wblb0 805:wblb0  r=5.53
r915 802:wblb0 822:wblb0  r=0.546
r914 802:wblb0 803:wblb0  r=0.119
r913 802:wblb0 xxwd0|xi0|mm0|drn  r=18
r912 801:wblb0 823:wblb0  r=0.49
r911 800:wblb0 801:wblb0  r=0.266
r910 799:wblb0 800:wblb0  r=0.266
r909 798:wblb0 799:wblb0  r=0.266
r908 797:wblb0 808:wblb0  r=1.981
r907 797:wblb0 798:wblb0  r=0.266
r906 795:wblb0 833:wblb0  r=0.07
r905 795:wblb0 wblb0  r=0.07
r904 795:wblb0 817:wblb0  r=2
r903 xxwd0|xi0|mm1|drn 801:wblb0  r=18
r902 xxwd0|xi0|mm1|drn 800:wblb0  r=18
r901 xxwd0|xi0|mm1|drn 799:wblb0  r=18
r900 xxwd0|xi0|mm1|drn 798:wblb0  r=18
r899 xxwd0|xi0|mm1|drn 797:wblb0  r=18
r898 794:wblb0 796:wblb0  r=7.12501
r897 794:wblb0 795:wblb0  r=18
r896 794:wblb0 xxwd0|xi1|mm0|gate  r=11.625
r895 xxwd0|xi1|mm1|gate 819:wblb0  r=13.51
r894 xxwd0|xi1|mm1|gate 796:wblb0  r=12.95
r893 792:wblb0 805:wblb0  r=18
r892 792:wblb0 xxarr|xi0|mpg2|src  r=7.5
r891 792:wblb0 793:wblb0  r=5.7
r890 790:wblb0 804:wblb0  r=18
r889 790:wblb0 xxarr|xi2|mpg2|src  r=7.5
r888 790:wblb0 791:wblb0  r=5.7
r887 wbl1 789:wbl1  r=0.0514
r886 wbl1 783:wbl1  r=0.05
r885 779:wbl1 786:wbl1  r=0.098
r884 779:wbl1 781:wbl1  r=0.098
r883 779:wbl1 780:wbl1  r=0.098
r882 779:wbl1 wbl1  r=2
r881 777:wbl1 785:wbl1  r=0.0514
r880 777:wbl1 784:wbl1  r=0.05
r879 776:wbl1 777:wbl1  r=2
r878 776:wbl1 779:wbl1  r=0.495786
r877 776:wbl1 787:wbl1  r=0.252
r876 776:wbl1 778:wbl1  r=0.098
r875 776:wbl1 782:wbl1  r=0.098
r874 775:wbl1 783:wbl1  r=0.994
r873 774:wbl1 788:wbl1  r=0.119
r872 774:wbl1 775:wbl1  r=5.53
r871 772:wbl1 773:wbl1  r=0.119
r870 772:wbl1 xxwd1|xi1|mm0|drn  r=18
r869 771:wbl1 772:wbl1  r=1.246
r868 770:wbl1 771:wbl1  r=0.266
r867 769:wbl1 770:wbl1  r=0.266
r866 768:wbl1 769:wbl1  r=0.266
r865 767:wbl1 784:wbl1  r=1.981
r864 767:wbl1 768:wbl1  r=0.266
r863 xxwd1|xi1|mm1|drn 771:wbl1  r=18
r862 xxwd1|xi1|mm1|drn 770:wbl1  r=18
r861 xxwd1|xi1|mm1|drn 769:wbl1  r=18
r860 xxwd1|xi1|mm1|drn 768:wbl1  r=18
r859 xxwd1|xi1|mm1|drn 767:wbl1  r=18
r858 766:wbl1 775:wbl1  r=18
r857 766:wbl1 xxarr|xi1|mpg1|drn  r=7.5
r856 765:wbl1 766:wbl1  r=5.7
r855 764:wbl1 774:wbl1  r=18
r854 764:wbl1 xxarr|xi3|mpg1|drn  r=7.5
r853 763:wbl1 764:wbl1  r=5.7
r852 749:wblb1 759:wblb1  r=0.098
r851 749:wblb1 758:wblb1  r=0.098
r850 749:wblb1 750:wblb1  r=0.098
r849 746:wblb1 760:wblb1  r=0.0514
r848 746:wblb1 755:wblb1  r=0.05
r847 745:wblb1 757:wblb1  r=0.098
r846 745:wblb1 748:wblb1  r=0.098
r845 745:wblb1 747:wblb1  r=0.098
r844 745:wblb1 746:wblb1  r=2
r843 742:wblb1 754:wblb1  r=0.05
r842 742:wblb1 752:wblb1  r=0.05
r841 741:wblb1 756:wblb1  r=0.098
r840 741:wblb1 749:wblb1  r=1.61
r839 741:wblb1 744:wblb1  r=0.098
r838 741:wblb1 743:wblb1  r=0.098
r837 741:wblb1 742:wblb1  r=2
r836 736:wblb1 753:wblb1  r=0.0514
r835 736:wblb1 737:wblb1  r=0.05
r834 735:wblb1 745:wblb1  r=0.514453
r833 735:wblb1 740:wblb1  r=0.098
r832 735:wblb1 739:wblb1  r=0.098
r831 735:wblb1 738:wblb1  r=0.252
r830 735:wblb1 736:wblb1  r=2
r829 734:wblb1 755:wblb1  r=0.994
r828 733:wblb1 761:wblb1  r=0.119
r827 733:wblb1 734:wblb1  r=5.53
r826 731:wblb1 752:wblb1  r=0.546
r825 731:wblb1 732:wblb1  r=0.119
r824 731:wblb1 xxwd1|xi0|mm0|drn  r=18
r823 730:wblb1 754:wblb1  r=0.49
r822 729:wblb1 730:wblb1  r=0.266
r821 728:wblb1 729:wblb1  r=0.266
r820 727:wblb1 728:wblb1  r=0.266
r819 726:wblb1 737:wblb1  r=1.981
r818 726:wblb1 727:wblb1  r=0.266
r817 724:wblb1 762:wblb1  r=0.07
r816 724:wblb1 wblb1  r=0.07
r815 724:wblb1 749:wblb1  r=2
r814 xxwd1|xi0|mm1|drn 730:wblb1  r=18
r813 xxwd1|xi0|mm1|drn 729:wblb1  r=18
r812 xxwd1|xi0|mm1|drn 728:wblb1  r=18
r811 xxwd1|xi0|mm1|drn 727:wblb1  r=18
r810 xxwd1|xi0|mm1|drn 726:wblb1  r=18
r809 723:wblb1 725:wblb1  r=7.12501
r808 723:wblb1 724:wblb1  r=18
r807 723:wblb1 xxwd1|xi1|mm0|gate  r=11.625
r806 xxwd1|xi1|mm1|gate 751:wblb1  r=13.51
r805 xxwd1|xi1|mm1|gate 725:wblb1  r=12.95
r804 721:wblb1 734:wblb1  r=18
r803 721:wblb1 xxarr|xi1|mpg2|src  r=7.5
r802 721:wblb1 722:wblb1  r=5.7
r801 719:wblb1 733:wblb1  r=18
r800 719:wblb1 xxarr|xi3|mpg2|src  r=7.5
r799 719:wblb1 720:wblb1  r=5.7
r798 711:rbl1 713:rbl1  r=0.098
r797 711:rbl1 712:rbl1  r=0.098
r796 710:rbl1 rbl1  r=0.098
r795 710:rbl1 711:rbl1  r=2
r794 706:rbl1 715:rbl1  r=0.05
r793 706:rbl1 707:rbl1  r=0.05
r792 705:rbl1 710:rbl1  r=2.64133
r791 705:rbl1 709:rbl1  r=0.098
r790 705:rbl1 708:rbl1  r=0.098
r789 705:rbl1 706:rbl1  r=2
r788 700:rbl1 716:rbl1  r=0.05
r787 700:rbl1 701:rbl1  r=0.0514
r786 699:rbl1 704:rbl1  r=0.098
r785 699:rbl1 703:rbl1  r=0.098
r784 699:rbl1 702:rbl1  r=0.098
r783 699:rbl1 700:rbl1  r=2
r782 698:rbl1 713:rbl1  r=2.975
r781 697:rbl1 698:rbl1  r=0.266
r780 696:rbl1 697:rbl1  r=0.266
r779 695:rbl1 696:rbl1  r=0.266
r778 694:rbl1 718:rbl1  r=0.119
r777 694:rbl1 695:rbl1  r=0.266
r776 692:rbl1 693:rbl1  r=0.119
r775 691:rbl1 716:rbl1  r=1.204
r774 691:rbl1 692:rbl1  r=5.53
r773 xxrs1|xis1|mm1|gate 714:rbl1  r=13.51
r772 690:rbl1 xxrs1|xis1|mm1|gate  r=12.95
r771 689:rbl1 717:rbl1  r=0.119
r770 689:rbl1 715:rbl1  r=2.422
r769 688:rbl1 699:rbl1  r=0.275333
r768 688:rbl1 705:rbl1  r=0.098
r767 xxrs1|mmpre|drn 698:rbl1  r=18
r766 xxrs1|mmpre|drn 697:rbl1  r=18
r765 xxrs1|mmpre|drn 696:rbl1  r=18
r764 xxrs1|mmpre|drn 695:rbl1  r=18
r763 xxrs1|mmpre|drn 694:rbl1  r=18
r762 687:rbl1 690:rbl1  r=7.12501
r761 687:rbl1 689:rbl1  r=18
r760 xxrs1|xis1|mm0|gate 687:rbl1  r=11.625
r759 685:rbl1 692:rbl1  r=18
r758 685:rbl1 xxarr|xi1|mra2|drn  r=7.5
r757 685:rbl1 686:rbl1  r=5.7
r756 683:rbl1 691:rbl1  r=18
r755 683:rbl1 xxarr|xi3|mra2|drn  r=7.5
r754 683:rbl1 684:rbl1  r=5.7
r753 681:ln_n_46 682:ln_n_46  r=4.158
r752 680:ln_n_46 681:ln_n_46  r=0.336
r751 679:ln_n_46 ln_n_46  r=6.601
r750 679:ln_n_46 680:ln_n_46  r=1.155
r749 661:wwl0 674:wwl0  r=0.098
r748 661:wwl0 662:wwl0  r=0.098
r747 660:wwl0 661:wwl0  r=2
r746 658:wwl0 673:wwl0  r=0.098
r745 658:wwl0 659:wwl0  r=0.098
r744 657:wwl0 676:wwl0  r=2.688
r743 657:wwl0 658:wwl0  r=2
r742 655:wwl0 656:wwl0  r=0.119
r741 654:wwl0 655:wwl0  r=0.266
r740 653:wwl0 654:wwl0  r=0.266
r739 652:wwl0 653:wwl0  r=0.266
r738 651:wwl0 652:wwl0  r=0.266
r737 650:wwl0 675:wwl0  r=1.771
r736 650:wwl0 651:wwl0  r=1.246
r735 649:wwl0 678:wwl0  r=0.119
r734 649:wwl0 674:wwl0  r=0.791
r733 648:wwl0 677:wwl0  r=0.119
r732 648:wwl0 673:wwl0  r=0.791
r731 647:wwl0 675:wwl0  r=0.05
r730 647:wwl0 663:wwl0  r=0.0514
r729 644:wwl0 672:wwl0  r=0.098
r728 644:wwl0 664:wwl0  r=0.049
r727 644:wwl0 647:wwl0  r=2
r726 644:wwl0 646:wwl0  r=0.0629066
r725 643:wwl0 644:wwl0  r=1.274
r724 643:wwl0 645:wwl0  r=7.79333
r723 642:wwl0 643:wwl0  r=2.73933
r722 642:wwl0 660:wwl0  r=0.0466666
r721 641:wwl0 657:wwl0  r=0.14
r720 641:wwl0 660:wwl0  r=2.688
r719 xxdec|xi1|mm1|drn 655:wwl0  r=18
r718 xxdec|xi1|mm1|drn 654:wwl0  r=18
r717 xxdec|xi1|mm1|drn 653:wwl0  r=18
r716 xxdec|xi1|mm1|drn 652:wwl0  r=18
r715 xxdec|xi1|mm1|drn 651:wwl0  r=18
r714 xxdec|xi1|mm0|drn 650:wwl0  r=18
r713 640:wwl0 wwl0  r=11.7
r712 xxarr|xi0|mpg1|gate 668:wwl0  r=9.00001
r711 xxarr|xi0|mpg1|gate 640:wwl0  r=9.00001
r710 639:wwl0 671:wwl0  r=11.7
r709 xxarr|xi0|mpg2|gate 667:wwl0  r=9.00001
r708 xxarr|xi0|mpg2|gate 639:wwl0  r=9.00001
r707 638:wwl0 670:wwl0  r=11.7
r706 xxarr|xi1|mpg1|gate 666:wwl0  r=9.00001
r705 xxarr|xi1|mpg1|gate 638:wwl0  r=9.00001
r704 637:wwl0 669:wwl0  r=11.7
r703 xxarr|xi1|mpg2|gate 665:wwl0  r=9.00001
r702 xxarr|xi1|mpg2|gate 637:wwl0  r=9.00001
r701 635:wwl0 649:wwl0  r=18
r700 635:wwl0 636:wwl0  r=5.44737
r699 634:wwl0 635:wwl0  r=5.44737
r698 633:wwl0 668:wwl0  r=23.85
r697 633:wwl0 636:wwl0  r=29
r696 632:wwl0 667:wwl0  r=23.85
r695 632:wwl0 633:wwl0  r=104
r694 630:wwl0 648:wwl0  r=18
r693 630:wwl0 631:wwl0  r=5.44737
r692 629:wwl0 630:wwl0  r=5.44737
r691 628:wwl0 666:wwl0  r=23.85
r690 628:wwl0 631:wwl0  r=29
r689 627:wwl0 665:wwl0  r=23.85
r688 627:wwl0 628:wwl0  r=104
r687 611:wwl1 621:wwl1  r=0.098
r686 611:wwl1 612:wwl1  r=0.098
r685 610:wwl1 611:wwl1  r=2
r684 608:wwl1 620:wwl1  r=0.098
r683 608:wwl1 609:wwl1  r=0.098
r682 607:wwl1 624:wwl1  r=2.688
r681 607:wwl1 608:wwl1  r=2
r680 605:wwl1 606:wwl1  r=0.119
r679 604:wwl1 605:wwl1  r=0.266
r678 603:wwl1 604:wwl1  r=0.266
r677 602:wwl1 603:wwl1  r=0.266
r676 601:wwl1 602:wwl1  r=0.266
r675 600:wwl1 623:wwl1  r=2.275
r674 600:wwl1 601:wwl1  r=1.246
r673 599:wwl1 626:wwl1  r=0.119
r672 599:wwl1 621:wwl1  r=0.791
r671 598:wwl1 625:wwl1  r=0.119
r670 598:wwl1 620:wwl1  r=0.791
r669 597:wwl1 623:wwl1  r=0.05
r668 597:wwl1 613:wwl1  r=0.0514
r667 594:wwl1 622:wwl1  r=0.098
r666 594:wwl1 614:wwl1  r=0.049
r665 594:wwl1 597:wwl1  r=2
r664 594:wwl1 596:wwl1  r=0.0629066
r663 593:wwl1 594:wwl1  r=1.47
r662 593:wwl1 595:wwl1  r=4.676
r661 592:wwl1 610:wwl1  r=0.0466666
r660 592:wwl1 593:wwl1  r=2.40333
r659 591:wwl1 607:wwl1  r=0.14
r658 591:wwl1 610:wwl1  r=2.688
r657 xxdec|xi2|mm1|drn 605:wwl1  r=18
r656 xxdec|xi2|mm1|drn 604:wwl1  r=18
r655 xxdec|xi2|mm1|drn 603:wwl1  r=18
r654 xxdec|xi2|mm1|drn 602:wwl1  r=18
r653 xxdec|xi2|mm1|drn 601:wwl1  r=18
r652 xxdec|xi2|mm0|drn 600:wwl1  r=18
r651 590:wwl1 wwl1  r=11.7
r650 xxarr|xi2|mpg1|gate 590:wwl1  r=9.00001
r649 589:wwl1 xxarr|xi2|mpg1|gate  r=9.00001
r648 588:wwl1 619:wwl1  r=11.7
r647 xxarr|xi2|mpg2|gate 616:wwl1  r=9.00001
r646 xxarr|xi2|mpg2|gate 588:wwl1  r=9.00001
r645 587:wwl1 618:wwl1  r=11.7
r644 xxarr|xi3|mpg1|gate 587:wwl1  r=9.00001
r643 586:wwl1 xxarr|xi3|mpg1|gate  r=9.00001
r642 585:wwl1 617:wwl1  r=11.7
r641 xxarr|xi3|mpg2|gate 615:wwl1  r=9.00001
r640 xxarr|xi3|mpg2|gate 585:wwl1  r=9.00001
r639 583:wwl1 599:wwl1  r=18
r638 583:wwl1 584:wwl1  r=5.44737
r637 582:wwl1 583:wwl1  r=5.44737
r636 581:wwl1 589:wwl1  r=23.85
r635 581:wwl1 584:wwl1  r=29
r634 580:wwl1 616:wwl1  r=23.85
r633 580:wwl1 581:wwl1  r=104
r632 578:wwl1 598:wwl1  r=18
r631 578:wwl1 579:wwl1  r=5.44737
r630 577:wwl1 578:wwl1  r=5.44737
r629 576:wwl1 586:wwl1  r=23.85
r628 576:wwl1 579:wwl1  r=29
r627 575:wwl1 615:wwl1  r=23.85
r626 575:wwl1 576:wwl1  r=104
r625 565:rbl0 569:rbl0  r=0.05
r624 565:rbl0 rbl0  r=0.05
r623 564:rbl0 572:rbl0  r=0.098
r622 564:rbl0 568:rbl0  r=0.098
r621 564:rbl0 566:rbl0  r=0.098
r620 564:rbl0 565:rbl0  r=2
r619 562:rbl0 564:rbl0  r=2.64133
r618 562:rbl0 563:rbl0  r=0.098
r617 561:rbl0 570:rbl0  r=2.975
r616 560:rbl0 561:rbl0  r=0.266
r615 559:rbl0 560:rbl0  r=0.266
r614 558:rbl0 559:rbl0  r=0.266
r613 556:rbl0 558:rbl0  r=0.266
r612 556:rbl0 557:rbl0  r=0.119
r611 555:rbl0 573:rbl0  r=0.119
r610 554:rbl0 571:rbl0  r=0.952
r609 554:rbl0 555:rbl0  r=5.53
r608 xxrs0|xis1|mm1|gate 567:rbl0  r=13.51
r607 553:rbl0 xxrs0|xis1|mm1|gate  r=12.95
r606 552:rbl0 574:rbl0  r=0.119
r605 552:rbl0 569:rbl0  r=2.422
r604 xxrs0|mmpre|drn 561:rbl0  r=18
r603 xxrs0|mmpre|drn 560:rbl0  r=18
r602 xxrs0|mmpre|drn 559:rbl0  r=18
r601 xxrs0|mmpre|drn 558:rbl0  r=18
r600 xxrs0|mmpre|drn 556:rbl0  r=18
r599 551:rbl0 553:rbl0  r=7.12501
r598 551:rbl0 552:rbl0  r=18
r597 551:rbl0 xxrs0|xis1|mm0|gate  r=11.625
r596 550:rbl0 570:rbl0  r=0.098
r595 550:rbl0 562:rbl0  r=2
r594 549:rbl0 571:rbl0  r=1.155
r593 549:rbl0 550:rbl0  r=0.238
r592 547:rbl0 555:rbl0  r=18
r591 547:rbl0 xxarr|xi0|mra2|drn  r=7.5
r590 547:rbl0 548:rbl0  r=5.7
r589 545:rbl0 554:rbl0  r=18
r588 545:rbl0 xxarr|xi2|mra2|drn  r=7.5
r587 545:rbl0 546:rbl0  r=5.7
r586 534:preb 542:preb  r=3.136
r585 531:preb 536:preb  r=0.098
r584 531:preb 532:preb  r=0.098
r583 531:preb preb  r=0.494666
r582 529:preb 543:preb  r=0.0514
r581 529:preb 534:preb  r=0.05
r580 528:preb 538:preb  r=0.098
r579 528:preb 530:preb  r=0.098
r578 528:preb 529:preb  r=2
r577 527:preb 528:preb  r=0.14
r576 526:preb 540:preb  r=0.494666
r575 526:preb 539:preb  r=0.098
r574 526:preb 535:preb  r=0.098
r573 526:preb 527:preb  r=0.448
r572 523:preb 525:preb  r=7.12501
r571 523:preb 524:preb  r=1.93
r570 522:preb 544:preb  r=0.138973
r569 522:preb 537:preb  r=0.138973
r568 522:preb 531:preb  r=2
r567 522:preb 523:preb  r=18
r566 519:preb 521:preb  r=7.12501
r565 519:preb 520:preb  r=1.93
r564 518:preb 541:preb  r=0.138973
r563 518:preb 533:preb  r=0.138973
r562 518:preb 526:preb  r=2
r561 518:preb 519:preb  r=18
r560 xxrs0|mmpre|gate 525:preb  r=12.95
r559 xxrs0|mmpre|gate 517:preb  r=14.55
r558 xxrs1|mmpre|gate 521:preb  r=12.95
r557 xxrs1|mmpre|gate 516:preb  r=14.55
r556 515:preb 531:preb  r=0.494666
r555 515:preb 528:preb  r=0.0933333
r554 513:ln_n_16 514:ln_n_16  r=0.001
r553 511:ln_n_16 512:ln_n_16  r=0.001
r552 511:ln_n_16 513:ln_n_16  r=0.1
r551 ln_n_16 511:ln_n_16  r=0.001
r550 ln_n_16 513:ln_n_16  r=0.001
r549 501:we 510:we  r=0.119
r548 501:we 504:we  r=3.493
r547 499:we 509:we  r=0.119
r546 499:we 502:we  r=3.493
r545 498:we 508:we  r=0.06
r544 498:we 504:we  r=0.05
r543 496:we 507:we  r=0.06
r542 496:we 502:we  r=0.05
r541 495:we 505:we  r=0.098
r540 495:we 498:we  r=2
r539 495:we 497:we  r=0.0629066
r538 xxdec|xn0|mm2|gate we  r=12.95
r537 xxdec|xn0|mm2|gate 492:we  r=14.55
r536 491:we we  r=7.12501
r535 491:we 501:we  r=18
r534 xxdec|xn0|mm0|gate 491:we  r=10.1875
r533 xxdec|xn1|mm2|gate 500:we  r=12.95
r532 xxdec|xn1|mm2|gate 490:we  r=14.55
r531 489:we 500:we  r=7.12501
r530 489:we 499:we  r=18
r529 xxdec|xn1|mm0|gate 489:we  r=10.1875
r528 488:we 506:we  r=0.098
r527 488:we 503:we  r=0.098
r526 488:we 496:we  r=2
r525 488:we 495:we  r=1.46067
r524 488:we 494:we  r=0.0629066
r523 487:we 495:we  r=0.882
r522 487:we 493:we  r=0.326667
r521 477:re 486:re  r=0.119
r520 477:re 481:re  r=3.997
r519 475:re 485:re  r=0.119
r518 475:re 478:re  r=3.997
r517 473:re 484:re  r=0.06
r516 473:re 481:re  r=0.05
r515 472:re 483:re  r=0.06
r514 472:re 478:re  r=0.05
r513 471:re 480:re  r=0.098
r512 471:re 474:re  r=0.0629066
r511 471:re 473:re  r=2
r510 468:re 471:re  r=3.80333
r509 468:re 469:re  r=0.326667
r508 xxdec|xn2|mm2|gate re  r=12.95
r507 xxdec|xn2|mm2|gate 467:re  r=14.55
r506 466:re re  r=7.12501
r505 466:re 477:re  r=18
r504 xxdec|xn2|mm0|gate 466:re  r=10.1875
r503 xxdec|xn3|mm2|gate 476:re  r=12.95
r502 xxdec|xn3|mm2|gate 465:re  r=14.55
r501 464:re 476:re  r=7.12501
r500 464:re 475:re  r=18
r499 xxdec|xn3|mm0|gate 464:re  r=10.1875
r498 463:re 482:re  r=0.098
r497 463:re 479:re  r=0.098
r496 463:re 472:re  r=2
r495 463:re 471:re  r=1.46067
r494 463:re 470:re  r=0.0629066
r493 449:a 460:a  r=0.119
r492 449:a 454:a  r=4.501
r491 447:a 462:a  r=0.119
r490 447:a 456:a  r=4.501
r489 445:a 461:a  r=0.119
r488 445:a 451:a  r=4.501
r487 444:a 454:a  r=0.05
r486 444:a 453:a  r=0.06
r485 442:a 458:a  r=0.098
r484 442:a 444:a  r=2
r483 442:a 443:a  r=0.0629066
r482 440:a 456:a  r=0.05
r481 440:a 455:a  r=0.06
r480 439:a 451:a  r=0.05
r479 439:a 450:a  r=0.06
r478 438:a 457:a  r=0.098
r477 438:a 442:a  r=2.33333
r476 438:a 441:a  r=0.0629066
r475 438:a 440:a  r=2
r474 435:a 442:a  r=0.294
r473 435:a 436:a  r=0.326667
r472 xxdec|xi0|mm1|gate a  r=12.95
r471 xxdec|xi0|mm1|gate 434:a  r=14.55
r470 433:a a  r=7.12501
r469 433:a 449:a  r=18
r468 xxdec|xi0|mm0|gate 433:a  r=10.1875
r467 xxdec|xn1|mm3|gate 448:a  r=12.95
r466 xxdec|xn1|mm3|gate 432:a  r=14.55
r465 431:a 448:a  r=7.12501
r464 431:a 447:a  r=18
r463 xxdec|xn1|mm1|gate 431:a  r=10.1875
r462 xxdec|xn3|mm3|gate 446:a  r=12.95
r461 xxdec|xn3|mm3|gate 430:a  r=14.55
r460 429:a 446:a  r=7.12501
r459 429:a 445:a  r=18
r458 xxdec|xn3|mm1|gate 429:a  r=10.1875
r457 428:a 459:a  r=0.098
r456 428:a 452:a  r=0.098
r455 428:a 439:a  r=2
r454 428:a 438:a  r=2.92133
r453 428:a 437:a  r=0.0629066
r452 417:rwl1 426:rwl1  r=0.098
r451 417:rwl1 420:rwl1  r=0.098
r450 417:rwl1 419:rwl1  r=0.098
r449 411:rwl1 424:rwl1  r=0.424666
r448 409:rwl1 410:rwl1  r=0.119
r447 408:rwl1 409:rwl1  r=0.266
r446 407:rwl1 408:rwl1  r=0.266
r445 406:rwl1 407:rwl1  r=0.266
r444 405:rwl1 406:rwl1  r=0.266
r443 404:rwl1 423:rwl1  r=3.283
r442 404:rwl1 405:rwl1  r=1.246
r441 402:rwl1 427:rwl1  r=0.130667
r440 402:rwl1 414:rwl1  r=0.130667
r439 402:rwl1 413:rwl1  r=2
r438 400:rwl1 425:rwl1  r=0.130667
r437 400:rwl1 412:rwl1  r=0.130667
r436 400:rwl1 411:rwl1  r=2
r435 399:rwl1 418:rwl1  r=0.0514
r434 399:rwl1 417:rwl1  r=2
r433 398:rwl1 423:rwl1  r=0.05
r432 398:rwl1 422:rwl1  r=0.0514
r431 397:rwl1 398:rwl1  r=7.217
r430 397:rwl1 399:rwl1  r=0.05
r429 396:rwl1 413:rwl1  r=2.31
r428 396:rwl1 417:rwl1  r=1.73133
r427 394:rwl1 416:rwl1  r=0.098
r426 394:rwl1 415:rwl1  r=0.049
r425 394:rwl1 398:rwl1  r=2
r424 394:rwl1 395:rwl1  r=0.303333
r423 393:rwl1 394:rwl1  r=0.0629066
r422 392:rwl1 413:rwl1  r=0.424666
r421 392:rwl1 411:rwl1  r=2.40333
r420 xxdec|xi4|mm1|drn 409:rwl1  r=18
r419 xxdec|xi4|mm1|drn 408:rwl1  r=18
r418 xxdec|xi4|mm1|drn 407:rwl1  r=18
r417 xxdec|xi4|mm1|drn 406:rwl1  r=18
r416 xxdec|xi4|mm1|drn 405:rwl1  r=18
r415 xxdec|xi4|mm0|drn 404:rwl1  r=18
r414 389:rwl1 rwl1  r=11.7
r413 xxarr|xi2|mra2|gate 389:rwl1  r=9.00001
r412 388:rwl1 xxarr|xi2|mra2|gate  r=9.00001
r411 388:rwl1 391:rwl1  r=11.7
r410 387:rwl1 390:rwl1  r=11.7
r409 386:rwl1 421:rwl1  r=11.7
r408 xxarr|xi3|mra2|gate 387:rwl1  r=9.00001
r407 xxarr|xi3|mra2|gate 386:rwl1  r=9.00001
r406 385:rwl1 391:rwl1  r=57.5527
r405 384:rwl1 403:rwl1  r=3.7174
r404 384:rwl1 402:rwl1  r=18
r403 384:rwl1 385:rwl1  r=1.07197
r402 383:rwl1 390:rwl1  r=57.5527
r401 382:rwl1 401:rwl1  r=3.7174
r400 382:rwl1 400:rwl1  r=18
r399 382:rwl1 383:rwl1  r=1.07197
r398 374:din0 380:din0  r=0.0514
r397 374:din0 377:din0  r=0.05
r396 373:din0 379:din0  r=0.098
r395 373:din0 378:din0  r=0.098
r394 373:din0 376:din0  r=0.098
r393 373:din0 din0  r=0.252
r392 373:din0 374:din0  r=2
r391 xxwd0|xi0|mm1|gate 375:din0  r=13.51
r390 372:din0 xxwd0|xi0|mm1|gate  r=12.95
r389 371:din0 381:din0  r=0.119
r388 371:din0 377:din0  r=2.569
r387 370:din0 372:din0  r=7.12501
r386 370:din0 371:din0  r=18
r385 370:din0 xxwd0|xi0|mm0|gate  r=11.625
r384 362:din1 368:din1  r=0.0514
r383 362:din1 365:din1  r=0.05
r382 361:din1 367:din1  r=0.098
r381 361:din1 366:din1  r=0.098
r380 361:din1 363:din1  r=0.098
r379 361:din1 din1  r=0.252
r378 361:din1 362:din1  r=2
r377 xxwd1|xi0|mm1|gate 364:din1  r=13.51
r376 360:din1 xxwd1|xi0|mm1|gate  r=12.95
r375 359:din1 369:din1  r=0.119
r374 359:din1 365:din1  r=2.569
r373 358:din1 360:din1  r=7.12501
r372 358:din1 359:din1  r=18
r371 358:din1 xxwd1|xi0|mm0|gate  r=11.625
r370 dout1 357:dout1  r=0.119
r369 356:dout1 dout1  r=1.246
r368 355:dout1 356:dout1  r=0.266
r367 354:dout1 355:dout1  r=0.266
r366 353:dout1 354:dout1  r=0.266
r365 xxrs1|xis2|mm1|drn 356:dout1  r=18
r364 xxrs1|xis2|mm1|drn 355:dout1  r=18
r363 xxrs1|xis2|mm1|drn 354:dout1  r=18
r362 xxrs1|xis2|mm1|drn 353:dout1  r=18
r361 351:dout1 353:dout1  r=0.266
r360 351:dout1 352:dout1  r=1.582
r359 351:dout1 xxrs1|xis2|mm1|drn  r=18
r358 xxrs1|xis2|mm0|drn dout1  r=18
r357 dout0 350:dout0  r=0.119
r356 349:dout0 dout0  r=1.246
r355 348:dout0 349:dout0  r=0.266
r354 347:dout0 348:dout0  r=0.266
r353 346:dout0 347:dout0  r=0.266
r352 xxrs0|xis2|mm1|drn 349:dout0  r=18
r351 xxrs0|xis2|mm1|drn 348:dout0  r=18
r350 xxrs0|xis2|mm1|drn 347:dout0  r=18
r349 xxrs0|xis2|mm1|drn 346:dout0  r=18
r348 344:dout0 346:dout0  r=0.266
r347 344:dout0 345:dout0  r=1.582
r346 344:dout0 xxrs0|xis2|mm1|drn  r=18
r345 xxrs0|xis2|mm0|drn dout0  r=18
r344 341:ln_xarr|x_r1c0|n_61 ln_xarr|x_r1c0|n_61  r=51.3001
r343 341:ln_xarr|x_r1c0|n_61 343:ln_xarr|x_r1c0|n_61  r=123.3
r342 341:ln_xarr|x_r1c0|n_61 342:ln_xarr|x_r1c0|n_61  r=7.43479
r341 339:ln_xrs1|n_33 ln_xrs1|n_33  r=2.611
r340 339:ln_xrs1|n_33 340:ln_xrs1|n_33  r=0.098
r339 338:ln_xrs1|n_33 339:ln_xrs1|n_33  r=0.098
r338 336:ln_xrs0|n_33 ln_xrs0|n_33  r=2.611
r337 336:ln_xrs0|n_33 337:ln_xrs0|n_33  r=0.098
r336 335:ln_xrs0|n_33 336:ln_xrs0|n_33  r=0.098
r335 333:ln_n_53 334:ln_n_53  r=0.1014
r334 331:ln_n_53 333:ln_n_53  r=7.217
r333 331:ln_n_53 332:ln_n_53  r=0.0514
r332 330:ln_n_53 ln_n_53  r=5.712
r331 330:ln_n_53 331:ln_n_53  r=0.05
r330 328:ln_n_54 329:ln_n_54  r=0.1014
r329 326:ln_n_54 328:ln_n_54  r=5.831
r328 326:ln_n_54 327:ln_n_54  r=0.0514
r327 325:ln_n_54 ln_n_54  r=5.208
r326 325:ln_n_54 326:ln_n_54  r=0.05
r325 323:ln_n_17 324:ln_n_17  r=0.001
r324 322:ln_n_17 323:ln_n_17  r=0.001
r323 321:ln_n_17 322:ln_n_17  r=0.1
r322 ln_n_17 321:ln_n_17  r=0.001
r321 ln_n_17 322:ln_n_17  r=0.001
r320 319:ln_xarr|x_r0c1|n_62 320:ln_xarr|x_r0c1|n_62  r=100.8
r319 318:ln_xarr|x_r0c1|n_62 ln_xarr|x_r0c1|n_62  r=64.8001
r318 318:ln_xarr|x_r0c1|n_62 319:ln_xarr|x_r0c1|n_62  r=10.6154
r317 316:ln_xarr|x_r0c0|n_62 317:ln_xarr|x_r0c0|n_62  r=100.8
r316 315:ln_xarr|x_r0c0|n_62 316:ln_xarr|x_r0c0|n_62  r=10.6154
r315 315:ln_xarr|x_r0c0|n_62 ln_xarr|x_r0c0|n_62  r=64.8001
r314 313:ln_xarr|x_r1c1|n_64 ln_xarr|x_r1c1|n_64  r=10.8947
r313 313:ln_xarr|x_r1c1|n_64 314:ln_xarr|x_r1c1|n_64  r=118.8
r312 311:ln_xarr|x_r0c1|n_64 312:ln_xarr|x_r0c1|n_64  r=118.8
r311 311:ln_xarr|x_r0c1|n_64 ln_xarr|x_r0c1|n_64  r=10.8947
r310 309:ln_xarr|x_r1c1|n_62 310:ln_xarr|x_r1c1|n_62  r=64.8001
r309 308:ln_xarr|x_r1c1|n_62 ln_xarr|x_r1c1|n_62  r=100.8
r308 308:ln_xarr|x_r1c1|n_62 309:ln_xarr|x_r1c1|n_62  r=10.6154
r307 306:ln_xarr|x_r1c0|n_64 ln_xarr|x_r1c0|n_64  r=10.8947
r306 306:ln_xarr|x_r1c0|n_64 307:ln_xarr|x_r1c0|n_64  r=118.8
r305 305:ln_xrs1|n_38 ln_xrs1|n_38  r=38.18
r304 304:ln_xrs0|n_38 ln_xrs0|n_38  r=38.18
r303 302:ln_xarr|x_r0c0|n_64 ln_xarr|x_r0c0|n_64  r=10.8947
r302 302:ln_xarr|x_r0c0|n_64 303:ln_xarr|x_r0c0|n_64  r=118.8
r301 300:ln_xarr|x_r1c0|n_62 301:ln_xarr|x_r1c0|n_62  r=64.8001
r300 299:ln_xarr|x_r1c0|n_62 ln_xarr|x_r1c0|n_62  r=100.8
r299 299:ln_xarr|x_r1c0|n_62 300:ln_xarr|x_r1c0|n_62  r=10.6154
r298 298:ln_n_48 ln_n_48  r=6.853
r297 297:ln_n_48 298:ln_n_48  r=0.1014
r296 295:ln_xrs1|i1|n_30 296:ln_xrs1|i1|n_30  r=1.918
r295 294:ln_xrs1|i1|n_30 ln_xrs1|i1|n_30  r=0.161
r294 294:ln_xrs1|i1|n_30 295:ln_xrs1|i1|n_30  r=0.457333
r293 292:ln_xrs1|i1|n_29 293:ln_xrs1|i1|n_29  r=0.21
r292 291:ln_xrs1|i1|n_29 ln_xrs1|i1|n_29  r=0.742
r291 291:ln_xrs1|i1|n_29 292:ln_xrs1|i1|n_29  r=0.457333
r290 290:ln_xwd1|n_17 ln_xwd1|n_17  r=0.665
r289 289:ln_xwd1|n_17 290:ln_xwd1|n_17  r=0.1
r288 288:ln_xwd1|n_17 289:ln_xwd1|n_17  r=3.535
r287 287:ln_xwd1|n_17 288:ln_xwd1|n_17  r=0.1014
r286 286:ln_xarr|x_r1c1|n_59 ln_xarr|x_r1c1|n_59  r=0.1001
r285 285:ln_xarr|x_r0c1|n_59 ln_xarr|x_r0c1|n_59  r=0.1001
r284 283:ln_xrs1|n_31 284:ln_xrs1|n_31  r=0.665
r283 282:ln_xrs1|n_31 ln_xrs1|n_31  r=1.673
r282 282:ln_xrs1|n_31 283:ln_xrs1|n_31  r=0.1
r281 281:ln_xarr|x_r1c1|n_57 ln_xarr|x_r1c1|n_57  r=0.567
r280 280:ln_xarr|x_r1c1|n_57 281:ln_xarr|x_r1c1|n_57  r=0.196
r279 279:ln_xarr|x_r0c1|n_57 ln_xarr|x_r0c1|n_57  r=0.567
r278 278:ln_xarr|x_r0c1|n_57 279:ln_xarr|x_r0c1|n_57  r=0.196
r277 277:ln_xwd1|n_20 ln_xwd1|n_20  r=2.688
r276 276:ln_xwd1|n_20 277:ln_xwd1|n_20  r=0.1014
r275 274:ln_xwd1|xwa|n_30 275:ln_xwd1|xwa|n_30  r=1.918
r274 273:ln_xwd1|xwa|n_30 ln_xwd1|xwa|n_30  r=0.161
r273 273:ln_xwd1|xwa|n_30 274:ln_xwd1|xwa|n_30  r=0.457333
r272 271:ln_xwd1|xwa|n_29 272:ln_xwd1|xwa|n_29  r=0.21
r271 270:ln_xwd1|xwa|n_29 ln_xwd1|xwa|n_29  r=0.742
r270 270:ln_xwd1|xwa|n_29 271:ln_xwd1|xwa|n_29  r=0.457333
r269 269:ln_n_49 ln_n_49  r=6.643
r268 268:ln_n_49 269:ln_n_49  r=0.1014
r267 266:ln_xrs1|i2|n_30 267:ln_xrs1|i2|n_30  r=1.918
r266 265:ln_xrs1|i2|n_30 ln_xrs1|i2|n_30  r=0.161
r265 265:ln_xrs1|i2|n_30 266:ln_xrs1|i2|n_30  r=0.457333
r264 263:ln_xrs1|i2|n_29 264:ln_xrs1|i2|n_29  r=0.21
r263 262:ln_xrs1|i2|n_29 ln_xrs1|i2|n_29  r=0.742
r262 262:ln_xrs1|i2|n_29 263:ln_xrs1|i2|n_29  r=0.457333
r261 260:ln_xarr|x_r1c1|n_48 261:ln_xarr|x_r1c1|n_48  r=0.539
r260 259:ln_xarr|x_r1c1|n_48 ln_xarr|x_r1c1|n_48  r=1.659
r259 259:ln_xarr|x_r1c1|n_48 260:ln_xarr|x_r1c1|n_48  r=0.196
r258 257:ln_xarr|x_r0c1|n_48 258:ln_xarr|x_r0c1|n_48  r=1.659
r257 256:ln_xarr|x_r0c1|n_48 ln_xarr|x_r0c1|n_48  r=0.539
r256 256:ln_xarr|x_r0c1|n_48 257:ln_xarr|x_r0c1|n_48  r=0.196
r255 254:ln_xarr|n_28 255:ln_xarr|n_28  r=0.287
r254 253:ln_xarr|n_28 ln_xarr|n_28  r=0.287
r253 253:ln_xarr|n_28 254:ln_xarr|n_28  r=0.457333
r252 252:ln_xarr|x_r1c1|n_53 ln_xarr|x_r1c1|n_53  r=0.567
r251 251:ln_xarr|x_r1c1|n_53 252:ln_xarr|x_r1c1|n_53  r=0.196
r250 250:ln_xarr|x_r0c1|n_53 ln_xarr|x_r0c1|n_53  r=0.567
r249 249:ln_xarr|x_r0c1|n_53 250:ln_xarr|x_r0c1|n_53  r=0.196
r248 248:ln_xarr|x_r1c1|n_60 ln_xarr|x_r1c1|n_60  r=0.1001
r247 247:ln_xarr|x_r0c1|n_60 ln_xarr|x_r0c1|n_60  r=0.1001
r246 246:ln_xwd1|n_18 ln_xwd1|n_18  r=4.41
r245 245:ln_xwd1|n_18 246:ln_xwd1|n_18  r=0.1014
r244 243:ln_xarr|x_r1c1|n_47 244:ln_xarr|x_r1c1|n_47  r=1.379
r243 242:ln_xarr|x_r1c1|n_47 ln_xarr|x_r1c1|n_47  r=0.819
r242 242:ln_xarr|x_r1c1|n_47 243:ln_xarr|x_r1c1|n_47  r=0.196
r241 240:ln_xarr|x_r0c1|n_47 241:ln_xarr|x_r0c1|n_47  r=0.819
r240 239:ln_xarr|x_r0c1|n_47 ln_xarr|x_r0c1|n_47  r=1.379
r239 239:ln_xarr|x_r0c1|n_47 240:ln_xarr|x_r0c1|n_47  r=0.196
r238 238:ln_n_50 ln_n_50  r=6.643
r237 237:ln_n_50 238:ln_n_50  r=0.1014
r236 235:ln_xwd1|xwb|n_30 236:ln_xwd1|xwb|n_30  r=1.918
r235 234:ln_xwd1|xwb|n_30 ln_xwd1|xwb|n_30  r=0.161
r234 234:ln_xwd1|xwb|n_30 235:ln_xwd1|xwb|n_30  r=0.457333
r233 232:ln_xwd1|xwb|n_29 233:ln_xwd1|xwb|n_29  r=0.21
r232 231:ln_xwd1|xwb|n_29 ln_xwd1|xwb|n_29  r=0.742
r231 231:ln_xwd1|xwb|n_29 232:ln_xwd1|xwb|n_29  r=0.457333
r230 229:ln_xrs1|n_34 230:ln_xrs1|n_34  r=1.918
r229 228:ln_xrs1|n_34 ln_xrs1|n_34  r=0.161
r228 228:ln_xrs1|n_34 229:ln_xrs1|n_34  r=0.457333
r227 227:ln_xarr|x_r1c1|n_52 ln_xarr|x_r1c1|n_52  r=0.91
r226 226:ln_xarr|x_r1c1|n_52 227:ln_xarr|x_r1c1|n_52  r=0.196
r225 225:ln_xarr|x_r0c1|n_52 ln_xarr|x_r0c1|n_52  r=0.91
r224 224:ln_xarr|x_r0c1|n_52 225:ln_xarr|x_r0c1|n_52  r=0.196
r223 223:ln_xrs1|n_36 ln_xrs1|n_36  r=0.277947
r222 222:ln_n__hercules_generated_62 ln_n__hercules_generated_62  r=4.158
r221 221:ln_n__hercules_generated_62 222:ln_n__hercules_generated_62  r=0.196
r220 220:ln_xwd0|n_17 ln_xwd0|n_17  r=0.665
r219 219:ln_xwd0|n_17 220:ln_xwd0|n_17  r=0.1
r218 218:ln_xwd0|n_17 219:ln_xwd0|n_17  r=3.535
r217 217:ln_xwd0|n_17 218:ln_xwd0|n_17  r=0.1014
r216 216:ln_n_55 ln_n_55  r=3.136
r215 215:ln_n_55 216:ln_n_55  r=0.1014
r214 214:ln_xarr|x_r1c0|n_59 ln_xarr|x_r1c0|n_59  r=0.1001
r213 213:ln_xarr|x_r0c0|n_59 ln_xarr|x_r0c0|n_59  r=0.1001
r212 212:ln_xarr|x_r1c0|n_57 ln_xarr|x_r1c0|n_57  r=0.567
r211 211:ln_xarr|x_r1c0|n_57 212:ln_xarr|x_r1c0|n_57  r=0.196
r210 210:ln_xarr|x_r0c0|n_57 ln_xarr|x_r0c0|n_57  r=0.567
r209 209:ln_xarr|x_r0c0|n_57 210:ln_xarr|x_r0c0|n_57  r=0.196
r208 208:ln_xwd0|n_20 ln_xwd0|n_20  r=2.688
r207 207:ln_xwd0|n_20 208:ln_xwd0|n_20  r=0.1014
r206 205:ln_xwd0|xwa|n_30 206:ln_xwd0|xwa|n_30  r=1.918
r205 204:ln_xwd0|xwa|n_30 ln_xwd0|xwa|n_30  r=0.161
r204 204:ln_xwd0|xwa|n_30 205:ln_xwd0|xwa|n_30  r=0.457333
r203 202:ln_xwd0|xwa|n_29 203:ln_xwd0|xwa|n_29  r=0.21
r202 201:ln_xwd0|xwa|n_29 ln_xwd0|xwa|n_29  r=0.742
r201 201:ln_xwd0|xwa|n_29 202:ln_xwd0|xwa|n_29  r=0.457333
r200 200:ln_n_51 ln_n_51  r=6.643
r199 199:ln_n_51 200:ln_n_51  r=0.1014
r198 198:ln_xrs0|n_36 ln_xrs0|n_36  r=0.277947
r197 196:ln_xarr|x_r1c0|n_48 197:ln_xarr|x_r1c0|n_48  r=0.539
r196 195:ln_xarr|x_r1c0|n_48 ln_xarr|x_r1c0|n_48  r=1.659
r195 195:ln_xarr|x_r1c0|n_48 196:ln_xarr|x_r1c0|n_48  r=0.196
r194 193:ln_xarr|x_r0c0|n_48 194:ln_xarr|x_r0c0|n_48  r=1.659
r193 192:ln_xarr|x_r0c0|n_48 ln_xarr|x_r0c0|n_48  r=0.539
r192 192:ln_xarr|x_r0c0|n_48 193:ln_xarr|x_r0c0|n_48  r=0.196
r191 190:ln_xrs0|n_34 191:ln_xrs0|n_34  r=1.918
r190 189:ln_xrs0|n_34 ln_xrs0|n_34  r=0.161
r189 189:ln_xrs0|n_34 190:ln_xrs0|n_34  r=0.457333
r188 187:ln_xarr|n_24 188:ln_xarr|n_24  r=0.287
r187 186:ln_xarr|n_24 ln_xarr|n_24  r=0.287
r186 186:ln_xarr|n_24 187:ln_xarr|n_24  r=0.457333
r185 185:ln_xarr|x_r1c0|n_53 ln_xarr|x_r1c0|n_53  r=0.567
r184 184:ln_xarr|x_r1c0|n_53 185:ln_xarr|x_r1c0|n_53  r=0.196
r183 183:ln_xarr|x_r0c0|n_53 ln_xarr|x_r0c0|n_53  r=0.567
r182 182:ln_xarr|x_r0c0|n_53 183:ln_xarr|x_r0c0|n_53  r=0.196
r181 181:ln_xarr|x_r1c0|n_60 ln_xarr|x_r1c0|n_60  r=0.1001
r180 180:ln_xarr|x_r0c0|n_60 ln_xarr|x_r0c0|n_60  r=0.1001
r179 179:ln_xwd0|n_18 ln_xwd0|n_18  r=4.41
r178 178:ln_xwd0|n_18 179:ln_xwd0|n_18  r=0.1014
r177 176:ln_xarr|x_r1c0|n_47 177:ln_xarr|x_r1c0|n_47  r=1.379
r176 175:ln_xarr|x_r1c0|n_47 ln_xarr|x_r1c0|n_47  r=0.819
r175 175:ln_xarr|x_r1c0|n_47 176:ln_xarr|x_r1c0|n_47  r=0.196
r174 173:ln_xarr|x_r0c0|n_47 174:ln_xarr|x_r0c0|n_47  r=0.819
r173 172:ln_xarr|x_r0c0|n_47 ln_xarr|x_r0c0|n_47  r=1.379
r172 172:ln_xarr|x_r0c0|n_47 173:ln_xarr|x_r0c0|n_47  r=0.196
r171 171:ln_n_52 ln_n_52  r=6.643
r170 170:ln_n_52 171:ln_n_52  r=0.1014
r169 168:ln_xwd0|xwb|n_30 169:ln_xwd0|xwb|n_30  r=1.918
r168 167:ln_xwd0|xwb|n_30 ln_xwd0|xwb|n_30  r=0.161
r167 167:ln_xwd0|xwb|n_30 168:ln_xwd0|xwb|n_30  r=0.457333
r166 165:ln_xwd0|xwb|n_29 166:ln_xwd0|xwb|n_29  r=0.21
r165 164:ln_xwd0|xwb|n_29 ln_xwd0|xwb|n_29  r=0.742
r164 164:ln_xwd0|xwb|n_29 165:ln_xwd0|xwb|n_29  r=0.457333
r163 163:ln_xarr|x_r1c0|n_52 ln_xarr|x_r1c0|n_52  r=0.91
r162 162:ln_xarr|x_r1c0|n_52 163:ln_xarr|x_r1c0|n_52  r=0.196
r161 161:ln_xarr|x_r0c0|n_52 ln_xarr|x_r0c0|n_52  r=0.91
r160 160:ln_xarr|x_r0c0|n_52 161:ln_xarr|x_r0c0|n_52  r=0.196
r159 158:ln_xrs0|i2|n_30 159:ln_xrs0|i2|n_30  r=1.918
r158 157:ln_xrs0|i2|n_30 ln_xrs0|i2|n_30  r=0.161
r157 157:ln_xrs0|i2|n_30 158:ln_xrs0|i2|n_30  r=0.457333
r156 155:ln_xrs0|i2|n_29 156:ln_xrs0|i2|n_29  r=0.21
r155 154:ln_xrs0|i2|n_29 ln_xrs0|i2|n_29  r=0.742
r154 154:ln_xrs0|i2|n_29 155:ln_xrs0|i2|n_29  r=0.457333
r153 153:ln_n_56 ln_n_56  r=0.1014
r152 152:ln_n_56 153:ln_n_56  r=2.8525
r151 151:ln_n_56 152:ln_n_56  r=0.1
r150 150:ln_n_56 151:ln_n_56  r=3.255
r149 149:ln_n_56 150:ln_n_56  r=0.1
r148 148:ln_n_56 149:ln_n_56  r=0.6825
r147 147:ln_n_56 148:ln_n_56  r=0.1014
r146 145:ln_xrs0|n_31 146:ln_xrs0|n_31  r=0.665
r145 144:ln_xrs0|n_31 ln_xrs0|n_31  r=1.673
r144 144:ln_xrs0|n_31 145:ln_xrs0|n_31  r=0.1
r143 143:ln_n_57 ln_n_57  r=0.1014
r142 142:ln_n_57 143:ln_n_57  r=2.6005
r141 141:ln_n_57 142:ln_n_57  r=0.1
r140 140:ln_n_57 141:ln_n_57  r=2.331
r139 139:ln_n_57 140:ln_n_57  r=0.1014
r138 137:ln_xrs0|i1|n_30 138:ln_xrs0|i1|n_30  r=1.918
r137 136:ln_xrs0|i1|n_30 ln_xrs0|i1|n_30  r=0.161
r136 136:ln_xrs0|i1|n_30 137:ln_xrs0|i1|n_30  r=0.457333
r135 134:ln_xrs0|i1|n_29 135:ln_xrs0|i1|n_29  r=0.21
r134 133:ln_xrs0|i1|n_29 ln_xrs0|i1|n_29  r=0.742
r133 133:ln_xrs0|i1|n_29 134:ln_xrs0|i1|n_29  r=0.457333
r132 131:ln_xdec|n_39 ln_xdec|n_39  r=4.704
r131 131:ln_xdec|n_39 132:ln_xdec|n_39  r=0.1014
r130 129:ln_xdec|n_40 ln_xdec|n_40  r=4.2
r129 129:ln_xdec|n_40 130:ln_xdec|n_40  r=0.1014
r128 127:ln_xdec|n3|n_44 128:ln_xdec|n3|n_44  r=0.161
r127 126:ln_xdec|n3|n_44 ln_xdec|n3|n_44  r=0.791
r126 126:ln_xdec|n3|n_44 127:ln_xdec|n3|n_44  r=0.457333
r125 124:ln_xdec|n2|n_44 125:ln_xdec|n2|n_44  r=0.161
r124 123:ln_xdec|n2|n_44 ln_xdec|n2|n_44  r=0.791
r123 123:ln_xdec|n2|n_44 124:ln_xdec|n2|n_44  r=0.457333
r122 121:ln_xdec|n1|n_44 122:ln_xdec|n1|n_44  r=0.161
r121 120:ln_xdec|n1|n_44 ln_xdec|n1|n_44  r=0.791
r120 120:ln_xdec|n1|n_44 121:ln_xdec|n1|n_44  r=0.457333
r119 118:ln_xdec|n0|n_44 119:ln_xdec|n0|n_44  r=0.161
r118 117:ln_xdec|n0|n_44 ln_xdec|n0|n_44  r=0.791
r117 117:ln_xdec|n0|n_44 118:ln_xdec|n0|n_44  r=0.457333
r116 115:ln_xdec|i4|n_29 116:ln_xdec|i4|n_29  r=0.21
r115 114:ln_xdec|i4|n_29 ln_xdec|i4|n_29  r=0.742
r114 114:ln_xdec|i4|n_29 115:ln_xdec|i4|n_29  r=0.457333
r113 112:ln_xdec|i3|n_29 113:ln_xdec|i3|n_29  r=0.21
r112 111:ln_xdec|i3|n_29 ln_xdec|i3|n_29  r=0.742
r111 111:ln_xdec|i3|n_29 112:ln_xdec|i3|n_29  r=0.457333
r110 109:ln_xdec|i2|n_29 110:ln_xdec|i2|n_29  r=0.21
r109 108:ln_xdec|i2|n_29 ln_xdec|i2|n_29  r=0.742
r108 108:ln_xdec|i2|n_29 109:ln_xdec|i2|n_29  r=0.457333
r107 106:ln_xdec|i1|n_29 107:ln_xdec|i1|n_29  r=0.21
r106 105:ln_xdec|i1|n_29 ln_xdec|i1|n_29  r=0.742
r105 105:ln_xdec|i1|n_29 106:ln_xdec|i1|n_29  r=0.457333
r104 103:ln_xdec|i0|n_29 104:ln_xdec|i0|n_29  r=0.21
r103 102:ln_xdec|i0|n_29 ln_xdec|i0|n_29  r=0.742
r102 102:ln_xdec|i0|n_29 103:ln_xdec|i0|n_29  r=0.457333
r101 101:ln_xdec|n3|n_46 ln_xdec|n3|n_46  r=0.546
r100 100:ln_xdec|n3|n_46 101:ln_xdec|n3|n_46  r=0.196
r99 99:ln_xdec|n2|n_46 ln_xdec|n2|n_46  r=0.546
r98 98:ln_xdec|n2|n_46 99:ln_xdec|n2|n_46  r=0.196
r97 97:ln_xdec|n1|n_46 ln_xdec|n1|n_46  r=0.546
r96 96:ln_xdec|n1|n_46 97:ln_xdec|n1|n_46  r=0.196
r95 95:ln_xdec|n0|n_46 ln_xdec|n0|n_46  r=0.546
r94 94:ln_xdec|n0|n_46 95:ln_xdec|n0|n_46  r=0.196
r93 93:ln_xdec|n3|n_41 ln_xdec|n3|n_41  r=0.196
r92 92:ln_xdec|n3|n_41 93:ln_xdec|n3|n_41  r=1.708
r91 91:ln_xdec|n2|n_41 ln_xdec|n2|n_41  r=0.196
r90 90:ln_xdec|n2|n_41 91:ln_xdec|n2|n_41  r=1.708
r89 89:ln_xdec|n1|n_41 ln_xdec|n1|n_41  r=0.196
r88 88:ln_xdec|n1|n_41 89:ln_xdec|n1|n_41  r=1.708
r87 87:ln_xdec|n0|n_41 ln_xdec|n0|n_41  r=0.196
r86 86:ln_xdec|n0|n_41 87:ln_xdec|n0|n_41  r=1.708
r85 84:ln_xdec|i4|n_30 85:ln_xdec|i4|n_30  r=1.918
r84 83:ln_xdec|i4|n_30 ln_xdec|i4|n_30  r=0.161
r83 83:ln_xdec|i4|n_30 84:ln_xdec|i4|n_30  r=0.457333
r82 81:ln_xdec|n3|n_42 82:ln_xdec|n3|n_42  r=1.918
r81 80:ln_xdec|n3|n_42 ln_xdec|n3|n_42  r=0.161
r80 80:ln_xdec|n3|n_42 81:ln_xdec|n3|n_42  r=0.457333
r79 78:ln_xdec|n3|n_43 79:ln_xdec|n3|n_43  r=1.918
r78 77:ln_xdec|n3|n_43 ln_xdec|n3|n_43  r=0.161
r77 77:ln_xdec|n3|n_43 78:ln_xdec|n3|n_43  r=0.457333
r76 75:ln_xdec|i3|n_30 76:ln_xdec|i3|n_30  r=1.918
r75 74:ln_xdec|i3|n_30 ln_xdec|i3|n_30  r=0.161
r74 74:ln_xdec|i3|n_30 75:ln_xdec|i3|n_30  r=0.457333
r73 72:ln_xdec|n2|n_42 73:ln_xdec|n2|n_42  r=1.918
r72 71:ln_xdec|n2|n_42 ln_xdec|n2|n_42  r=0.161
r71 71:ln_xdec|n2|n_42 72:ln_xdec|n2|n_42  r=0.457333
r70 69:ln_xdec|n2|n_43 70:ln_xdec|n2|n_43  r=1.918
r69 68:ln_xdec|n2|n_43 ln_xdec|n2|n_43  r=0.161
r68 68:ln_xdec|n2|n_43 69:ln_xdec|n2|n_43  r=0.457333
r67 66:ln_xdec|i2|n_30 67:ln_xdec|i2|n_30  r=1.918
r66 65:ln_xdec|i2|n_30 ln_xdec|i2|n_30  r=0.161
r65 65:ln_xdec|i2|n_30 66:ln_xdec|i2|n_30  r=0.457333
r64 63:ln_xdec|n1|n_42 64:ln_xdec|n1|n_42  r=1.918
r63 62:ln_xdec|n1|n_42 ln_xdec|n1|n_42  r=0.161
r62 62:ln_xdec|n1|n_42 63:ln_xdec|n1|n_42  r=0.457333
r61 60:ln_xdec|n1|n_43 61:ln_xdec|n1|n_43  r=1.918
r60 59:ln_xdec|n1|n_43 ln_xdec|n1|n_43  r=0.161
r59 59:ln_xdec|n1|n_43 60:ln_xdec|n1|n_43  r=0.457333
r58 57:ln_xdec|i1|n_30 58:ln_xdec|i1|n_30  r=1.918
r57 56:ln_xdec|i1|n_30 ln_xdec|i1|n_30  r=0.161
r56 56:ln_xdec|i1|n_30 57:ln_xdec|i1|n_30  r=0.457333
r55 54:ln_xdec|n0|n_42 55:ln_xdec|n0|n_42  r=1.918
r54 53:ln_xdec|n0|n_42 ln_xdec|n0|n_42  r=0.161
r53 53:ln_xdec|n0|n_42 54:ln_xdec|n0|n_42  r=0.457333
r52 51:ln_xdec|n0|n_43 52:ln_xdec|n0|n_43  r=1.918
r51 50:ln_xdec|n0|n_43 ln_xdec|n0|n_43  r=0.161
r50 50:ln_xdec|n0|n_43 51:ln_xdec|n0|n_43  r=0.457333
r49 48:ln_xdec|i0|n_30 49:ln_xdec|i0|n_30  r=1.918
r48 47:ln_xdec|i0|n_30 ln_xdec|i0|n_30  r=0.161
r47 47:ln_xdec|i0|n_30 48:ln_xdec|i0|n_30  r=0.457333
r46 46:ln_xdec|n_45 ln_xdec|n_45  r=3.612
r45 45:ln_xdec|n_45 46:ln_xdec|n_45  r=0.11
r44 44:ln_xdec|n_43 ln_xdec|n_43  r=3.612
r43 43:ln_xdec|n_43 44:ln_xdec|n_43  r=0.11
r42 42:ln_xdec|n_49 ln_xdec|n_49  r=4.116
r41 41:ln_xdec|n_49 42:ln_xdec|n_49  r=0.11
r40 40:ln_xdec|n_47 ln_xdec|n_47  r=4.116
r39 39:ln_xdec|n_47 40:ln_xdec|n_47  r=0.11
r38 38:ln_xdec|n_50 ln_xdec|n_50  r=4.62
r37 37:ln_xdec|n_50 38:ln_xdec|n_50  r=0.11
r36 36:ln_xdec|n_46 ln_xdec|n_46  r=4.62
r35 35:ln_xdec|n_46 36:ln_xdec|n_46  r=0.11
r34 34:ln_xdec|n_42 ln_xdec|n_42  r=4.62
r33 33:ln_xdec|n_42 34:ln_xdec|n_42  r=0.11
r32 32:ln_xdec|n_48 ln_xdec|n_48  r=5.124
r31 31:ln_xdec|n_48 32:ln_xdec|n_48  r=0.11
r30 30:ln_xdec|n_44 ln_xdec|n_44  r=5.124
r29 29:ln_xdec|n_44 30:ln_xdec|n_44  r=0.11
r28 28:ln_xdec|n_41 ln_xdec|n_41  r=5.775
r27 27:ln_xdec|n_41 28:ln_xdec|n_41  r=0.11
r26 26:ln_xwd1|n_19 ln_xwd1|n_19  r=0.14
r25 25:ln_xwd0|n_19 ln_xwd0|n_19  r=0.14
r24 24:ln_xrs1|n_32 ln_xrs1|n_32  r=0.14
r23 23:ln_xrs0|n_32 ln_xrs0|n_32  r=0.14
r22 22:ln_xdec|n3|n_45 ln_xdec|n3|n_45  r=0.265263
r21 21:ln_xdec|n2|n_45 ln_xdec|n2|n_45  r=0.265263
r20 20:ln_xdec|n1|n_45 ln_xdec|n1|n_45  r=0.265263
r19 19:ln_xdec|n0|n_45 ln_xdec|n0|n_45  r=0.265263
r18 18:ln_xdec|n_54 ln_xdec|n_54  r=0.14
r17 17:ln_xdec|n_53 ln_xdec|n_53  r=0.14
r16 16:ln_xdec|n_52 ln_xdec|n_52  r=0.14
r15 15:ln_xdec|n_51 ln_xdec|n_51  r=0.14
r14 14:ln_xarr|x_r1c1|n_58 ln_xarr|x_r1c1|n_58  r=0.14
r13 13:ln_xarr|x_r1c1|n_54 ln_xarr|x_r1c1|n_54  r=0.261333
r12 12:ln_xarr|x_r1c1|n_51 ln_xarr|x_r1c1|n_51  r=0.261333
r11 11:ln_xarr|x_r1c0|n_58 ln_xarr|x_r1c0|n_58  r=0.14
r10 10:ln_xarr|x_r1c0|n_54 ln_xarr|x_r1c0|n_54  r=0.261333
r9 9:ln_xarr|x_r1c0|n_51 ln_xarr|x_r1c0|n_51  r=0.261333
r8 8:ln_xarr|x_r0c1|n_58 ln_xarr|x_r0c1|n_58  r=0.14
r7 7:ln_xarr|x_r0c1|n_54 ln_xarr|x_r0c1|n_54  r=0.261333
r6 6:ln_xarr|x_r0c1|n_51 ln_xarr|x_r0c1|n_51  r=0.261333
r5 5:ln_xarr|x_r0c0|n_58 ln_xarr|x_r0c0|n_58  r=0.14
r4 4:ln_xarr|x_r0c0|n_54 ln_xarr|x_r0c0|n_54  r=0.261333
r3 3:ln_xarr|x_r0c0|n_51 ln_xarr|x_r0c0|n_51  r=0.261333
r2 2:ln_n_47 ln_n_47  r=4.011
r1 1:ln_n_45 ln_n_45  r=4.011
cg2782 1443:ln_n_15 0  c=2.21867e-16
c2781 1443:ln_n_15 1227:xxdec|ab  c=4.34537e-18
c2780 1443:ln_n_15 1231:xxdec|ab  c=9.25226e-18
c2779 1443:ln_n_15 1233:xxdec|ab  c=8.89924e-18
c2778 1443:ln_n_15 1232:xxdec|ab  c=2.75585e-18
c2777 1443:ln_n_15 506:we  c=5.9039e-19
c2776 1443:ln_n_15 509:we  c=9.25226e-18
c2775 1443:ln_n_15 510:we  c=9.02544e-18
c2774 1443:ln_n_15 482:re  c=9.22676e-18
c2773 1443:ln_n_15 468:re  c=8.30954e-19
c2772 1443:ln_n_15 485:re  c=8.85396e-18
c2771 1443:ln_n_15 486:re  c=9.25226e-18
c2770 1443:ln_n_15 xxdec|xn0|mm1|gate  c=2.33976e-18
c2769 1443:ln_n_15 xxdec|xn0|mm0|gate  c=2.48907e-19
c2768 1443:ln_n_15 459:a  c=7.61466e-18
c2767 1443:ln_n_15 xxdec|xi0|mm0|gate  c=1.66034e-18
c2766 1443:ln_n_15 435:a  c=6.42895e-19
c2765 1443:ln_n_15 461:a  c=8.91267e-18
c2764 1443:ln_n_15 462:a  c=9.25226e-18
c2763 1443:ln_n_15 460:a  c=2.845e-18
cg2762 1430:ln_n_15 0  c=1.78928e-15
c2761 1430:ln_n_15 782:wbl1  c=8.38545e-20
c2760 1430:ln_n_15 301:ln_xarr|x_r1c0|n_62  c=1.10385e-18
c2759 1430:ln_n_15 xxdec|xn3|mm1|gate  c=7.00311e-17
c2758 1430:ln_n_15 299:ln_xarr|x_r1c0|n_62  c=1.69327e-18
c2757 1430:ln_n_15 xxdec|xn3|mm0|gate  c=6.70274e-17
c2756 1430:ln_n_15 317:ln_xarr|x_r0c0|n_62  c=1.69327e-18
c2755 1430:ln_n_15 315:ln_xarr|x_r0c0|n_62  c=1.10385e-18
c2754 1430:ln_n_15 300:ln_xarr|x_r1c0|n_62  c=3.58563e-19
c2753 1430:ln_n_15 316:ln_xarr|x_r0c0|n_62  c=3.58563e-19
c2752 1430:ln_n_15 786:wbl1  c=8.30717e-20
c2751 1430:ln_n_15 343:ln_xarr|x_r1c0|n_61  c=6.67551e-18
c2750 1430:ln_n_15 780:wbl1  c=1.24608e-19
c2749 1430:ln_n_15 342:ln_xarr|x_r1c0|n_61  c=1.62816e-18
c2748 1430:ln_n_15 781:wbl1  c=1.37456e-19
c2747 1430:ln_n_15 341:ln_xarr|x_r1c0|n_61  c=2.53829e-18
c2746 1430:ln_n_15 865:ln_xarr|x_r0c0|n_61  c=2.09216e-18
c2745 1430:ln_n_15 866:ln_xarr|x_r0c0|n_61  c=1.50292e-18
c2744 1430:ln_n_15 864:ln_xarr|x_r0c0|n_61  c=6.60245e-18
c2743 1430:ln_n_15 423:rwl1  c=3.18729e-17
c2742 1430:ln_n_15 907:rwl0  c=3.00721e-17
c2741 1430:ln_n_15 784:wbl1  c=6.12693e-19
c2740 1430:ln_n_15 785:wbl1  c=1.0256e-19
c2739 1430:ln_n_15 688:rbl1  c=1.06608e-19
c2738 1430:ln_n_15 623:wwl1  c=2.44805e-17
c2737 1430:ln_n_15 819:wblb0  c=1.52182e-17
c2736 1430:ln_n_15 675:wwl0  c=1.67197e-17
c2735 1430:ln_n_15 821:wblb0  c=1.76859e-19
c2734 1430:ln_n_15 1056:ln_xarr|x_r1c0|n_63  c=1.51354e-18
c2733 1430:ln_n_15 820:wblb0  c=1.0652e-19
c2732 1430:ln_n_15 1057:ln_xarr|x_r1c0|n_63  c=1.72644e-18
c2731 1430:ln_n_15 1048:ln_xarr|x_r0c0|n_63  c=1.60299e-18
c2730 1430:ln_n_15 788:wbl1  c=2.89907e-18
c2729 1430:ln_n_15 1049:ln_xarr|x_r0c0|n_63  c=1.74816e-18
c2728 1430:ln_n_15 789:wbl1  c=1.30235e-19
c2727 1430:ln_n_15 783:wbl1  c=1.69606e-19
c2726 1430:ln_n_15 567:rbl0  c=1.1917e-17
c2725 1430:ln_n_15 826:wblb0  c=1.59887e-19
c2724 1430:ln_n_15 815:wblb0  c=2.39831e-19
c2723 1430:ln_n_15 816:wblb0  c=2.56964e-19
c2722 1430:ln_n_15 625:wwl1  c=4.07654e-20
c2721 1430:ln_n_15 677:wwl0  c=6.36764e-20
c2720 1430:ln_n_15 620:wwl1  c=4.65344e-20
c2719 1430:ln_n_15 673:wwl0  c=4.65344e-20
c2718 1430:ln_n_15 1133:ln_xarr|x_r1c1|n_63  c=3.18415e-19
c2717 1430:ln_n_15 855:wbl0  c=4.18357e-19
c2716 1430:ln_n_15 573:rbl0  c=1.31481e-18
c2715 1430:ln_n_15 718:rbl1  c=1.61842e-19
c2714 1430:ln_n_15 827:wblb0  c=7.66956e-19
c2713 1430:ln_n_15 713:rbl1  c=2.94816e-19
c2712 1430:ln_n_15 818:wblb0  c=1.08823e-18
c2711 1430:ln_n_15 828:wblb0  c=1.35435e-18
c2710 1430:ln_n_15 509:we  c=1.04599e-17
c2709 1430:ln_n_15 510:we  c=9.48884e-18
c2708 1430:ln_n_15 853:wbl0  c=5.78539e-19
c2707 1430:ln_n_15 852:wbl0  c=7.71525e-19
c2706 1430:ln_n_15 851:wbl0  c=8.77003e-19
c2705 1430:ln_n_15 822:wblb0  c=5.13397e-19
c2704 1430:ln_n_15 825:wblb0  c=3.32029e-19
c2703 1430:ln_n_15 485:re  c=9.92526e-18
c2702 1430:ln_n_15 486:re  c=1.05463e-17
c2701 1430:ln_n_15 461:a  c=8.75446e-18
c2700 1430:ln_n_15 462:a  c=9.31064e-18
c2699 1430:ln_n_15 460:a  c=3.7361e-18
c2698 1430:ln_n_15 568:rbl0  c=8.7932e-19
c2697 1430:ln_n_15 566:rbl0  c=7.79799e-18
c2696 1430:ln_n_15 572:rbl0  c=6.61043e-18
c2695 1430:ln_n_15 416:rwl1  c=3.74901e-19
c2694 1430:ln_n_15 570:rbl0  c=2.20629e-19
c2693 1430:ln_n_15 1231:xxdec|ab  c=9.34881e-18
c2692 1430:ln_n_15 415:rwl1  c=1.64774e-18
c2691 1430:ln_n_15 1233:xxdec|ab  c=8.54545e-18
c2690 1430:ln_n_15 426:rwl1  c=2.02734e-18
c2689 1430:ln_n_15 571:rbl0  c=2.42679e-19
c2688 1430:ln_n_15 1232:xxdec|ab  c=1.19912e-17
c2687 1430:ln_n_15 420:rwl1  c=9.4507e-18
c2686 1430:ln_n_15 832:wblb0  c=2.14421e-18
c2685 1430:ln_n_15 394:rwl1  c=2.97763e-19
c2684 1430:ln_n_15 831:wblb0  c=2.60223e-19
c2683 1430:ln_n_15 1407:ln_xarr|x_r1c0|n_65  c=1.11784e-19
c2682 1430:ln_n_15 396:rwl1  c=3.85008e-17
c2681 1430:ln_n_15 910:rwl0  c=2.41506e-18
c2680 1430:ln_n_15 905:rwl0  c=3.84499e-17
c2679 1430:ln_n_15 1053:ln_xarr|x_r1c0|n_63  c=3.3278e-18
c2678 1430:ln_n_15 1055:ln_xarr|x_r1c0|n_63  c=7.21042e-19
c2677 1430:ln_n_15 909:rwl0  c=2.29131e-18
c2676 1430:ln_n_15 901:rwl0  c=6.24418e-18
c2675 1430:ln_n_15 824:wblb0  c=3.26343e-19
c2674 1430:ln_n_15 878:rwl0  c=1.10645e-18
c2673 1430:ln_n_15 876:rwl0  c=4.37186e-17
c2672 1430:ln_n_15 592:wwl1  c=4.77237e-17
c2671 1430:ln_n_15 622:wwl1  c=5.92293e-18
c2670 1430:ln_n_15 593:wwl1  c=8.2879e-17
c2669 1430:ln_n_15 594:wwl1  c=3.03321e-18
c2668 1430:ln_n_15 642:wwl0  c=8.63185e-17
c2667 1430:ln_n_15 672:wwl0  c=8.23171e-18
c2666 1430:ln_n_15 643:wwl0  c=1.20732e-16
c2665 1430:ln_n_15 644:wwl0  c=2.48755e-18
c2664 1430:ln_n_15 776:wbl1  c=5.5903e-20
c2663 1430:ln_n_15 xxdec|xi0|mm0|gate  c=1.66168e-17
c2662 1430:ln_n_15 856:wbl0  c=1.15092e-18
c2661 1430:ln_n_15 806:wblb0  c=1.17906e-19
c2660 1430:ln_n_15 857:wbl0  c=6.15925e-19
c2659 1430:ln_n_15 1121:ln_xarr|x_r0c1|n_63  c=2.80866e-19
c2658 1430:ln_n_15 833:wblb0  c=1.47453e-18
c2657 1430:ln_n_15 859:wbl0  c=2.56133e-17
c2656 1430:ln_n_15 860:wbl0  c=8.77129e-19
c2655 1430:ln_n_15 506:we  c=4.69148e-19
c2654 1430:ln_n_15 854:wbl0  c=1.15764e-18
c2653 1430:ln_n_15 847:wbl0  c=3.1588e-19
c2652 1430:ln_n_15 482:re  c=7.65152e-18
c2651 1430:ln_n_15 626:wwl1  c=2.30376e-18
c2650 1430:ln_n_15 678:wwl0  c=2.35112e-18
c2649 1430:ln_n_15 621:wwl1  c=1.3437e-18
c2648 1430:ln_n_15 674:wwl0  c=1.3437e-18
c2647 1430:ln_n_15 459:a  c=6.49138e-18
c2646 1430:ln_n_15 549:rbl0  c=4.46776e-19
c2645 1430:ln_n_15 1227:xxdec|ab  c=4.03677e-18
c2644 1430:ln_n_15 574:rbl0  c=6.89324e-18
c2643 1430:ln_n_15 569:rbl0  c=1.23382e-17
c2642 1430:ln_n_15 1050:ln_xarr|x_r0c0|n_65  c=6.83594e-19
c2641 1430:ln_n_15 1045:ln_xarr|x_r0c0|n_63  c=2.98909e-18
c2640 1430:ln_n_15 xxdec|xn0|mm1|gate  c=6.8647e-17
c2639 1430:ln_n_15 1047:ln_xarr|x_r0c0|n_63  c=7.48299e-19
c2638 1430:ln_n_15 xxdec|xn0|mm0|gate  c=6.74964e-17
c2637 1430:ln_n_15 981:ln_xarr|x_r1c1|n_61  c=8.62614e-19
c2636 1430:ln_n_15 980:ln_xarr|x_r1c1|n_61  c=1.91261e-19
c2635 1430:ln_n_15 979:ln_xarr|x_r1c1|n_61  c=2.9785e-19
c2634 1430:ln_n_15 914:ln_xarr|x_r0c1|n_61  c=2.80183e-19
c2633 1430:ln_n_15 915:ln_xarr|x_r0c1|n_61  c=1.91261e-19
c2632 1430:ln_n_15 418:rwl1  c=7.82009e-18
c2631 1430:ln_n_15 422:rwl1  c=3.3068e-18
c2630 1430:ln_n_15 913:ln_xarr|x_r0c1|n_61  c=8.52093e-19
c2629 1430:ln_n_15 397:rwl1  c=1.05801e-16
c2628 1430:ln_n_15 906:rwl0  c=6.74109e-18
c2627 1430:ln_n_15 898:rwl0  c=4.41698e-18
c2626 1430:ln_n_15 xxdec|xn1|mm1|gate  c=7.28462e-17
c2625 1430:ln_n_15 880:rwl0  c=1.08622e-16
c2624 1430:ln_n_15 1136:ln_xarr|x_r1c1|n_63  c=1.13683e-19
c2623 1430:ln_n_15 xxdec|xn1|mm0|gate  c=6.90696e-17
c2622 1430:ln_n_15 613:wwl1  c=1.0051e-17
c2621 1430:ln_n_15 1137:ln_xarr|x_r1c1|n_63  c=1.27886e-19
c2620 1430:ln_n_15 663:wwl0  c=1.27918e-17
c2619 1430:ln_n_15 1124:ln_xarr|x_r0c1|n_63  c=1.4557e-19
c2618 1430:ln_n_15 1125:ln_xarr|x_r0c1|n_63  c=1.63636e-19
c2617 1430:ln_n_15 1410:ln_xarr|x_r1c0|n_65  c=2.16602e-19
c2616 1430:ln_n_15 1409:ln_xarr|x_r1c0|n_65  c=5.7181e-19
c2615 1430:ln_n_15 1051:ln_xarr|x_r0c0|n_65  c=2.07966e-19
c2614 1430:ln_n_15 1408:ln_xarr|x_r1c0|n_65  c=2.32577e-20
c2613 1430:ln_n_15 xxdec|xn2|mm1|gate  c=7.30432e-17
c2612 1430:ln_n_15 1052:ln_xarr|x_r0c0|n_65  c=2.32577e-20
c2611 1430:ln_n_15 xxdec|xn2|mm0|gate  c=6.92851e-17
c2610 1430:ln_n_15 307:ln_xarr|x_r1c0|n_64  c=2.3492e-18
c2609 1430:ln_n_15 303:ln_xarr|x_r0c0|n_64  c=2.34919e-18
c2608 1430:ln_n_15 306:ln_xarr|x_r1c0|n_64  c=4.41506e-19
c2607 1430:ln_n_15 302:ln_xarr|x_r0c0|n_64  c=4.41506e-19
cg2606 1421:ln_n_15 0  c=1.21947e-17
c2605 1421:ln_n_15 1233:xxdec|ab  c=1.45954e-19
c2604 1421:ln_n_15 1232:xxdec|ab  c=3.32573e-19
c2603 1421:ln_n_15 460:a  c=4.81223e-19
c2602 1421:ln_n_15 510:we  c=1.14926e-19
c2601 1421:ln_n_15 435:a  c=7.54143e-19
c2600 1421:ln_n_15 468:re  c=1.00203e-18
cg2599 xxwd0|xi1|mm0|bulk 0  c=1.12806e-15
c2598 xxwd0|xi1|mm0|bulk 782:wbl1  c=1.49434e-18
c2597 xxwd0|xi1|mm0|bulk 301:ln_xarr|x_r1c0|n_62  c=1.3247e-17
c2596 xxwd0|xi1|mm0|bulk 299:ln_xarr|x_r1c0|n_62  c=2.62923e-17
c2595 xxwd0|xi1|mm0|bulk 317:ln_xarr|x_r0c0|n_62  c=2.69057e-17
c2594 xxwd0|xi1|mm0|bulk 315:ln_xarr|x_r0c0|n_62  c=1.31206e-17
c2593 xxwd0|xi1|mm0|bulk 300:ln_xarr|x_r1c0|n_62  c=9.46392e-18
c2592 xxwd0|xi1|mm0|bulk 316:ln_xarr|x_r0c0|n_62  c=9.3534e-18
c2591 xxwd0|xi1|mm0|bulk 786:wbl1  c=1.16535e-18
c2590 xxwd0|xi1|mm0|bulk 343:ln_xarr|x_r1c0|n_61  c=2.89542e-17
c2589 xxwd0|xi1|mm0|bulk 780:wbl1  c=1.99888e-18
c2588 xxwd0|xi1|mm0|bulk 342:ln_xarr|x_r1c0|n_61  c=8.65952e-18
c2587 xxwd0|xi1|mm0|bulk 781:wbl1  c=2.40833e-18
c2586 xxwd0|xi1|mm0|bulk 624:wwl1  c=2.93515e-17
c2585 xxwd0|xi1|mm0|bulk 341:ln_xarr|x_r1c0|n_61  c=1.04034e-17
c2584 xxwd0|xi1|mm0|bulk 424:rwl1  c=3.16768e-17
c2583 xxwd0|xi1|mm0|bulk 865:ln_xarr|x_r0c0|n_61  c=9.84462e-18
c2582 xxwd0|xi1|mm0|bulk 908:rwl0  c=3.03845e-17
c2581 xxwd0|xi1|mm0|bulk 676:wwl0  c=2.92081e-17
c2580 xxwd0|xi1|mm0|bulk 866:ln_xarr|x_r0c0|n_61  c=8.6551e-18
c2579 xxwd0|xi1|mm0|bulk 864:ln_xarr|x_r0c0|n_61  c=2.88837e-17
c2578 xxwd0|xi1|mm0|bulk 784:wbl1  c=5.71839e-18
c2577 xxwd0|xi1|mm0|bulk 785:wbl1  c=5.29607e-18
c2576 xxwd0|xi1|mm0|bulk 688:rbl1  c=3.40086e-17
c2575 xxwd0|xi1|mm0|bulk 819:wblb0  c=4.27291e-18
c2574 xxwd0|xi1|mm0|bulk 830:wblb0  c=2.4148e-18
c2573 xxwd0|xi1|mm0|bulk 821:wblb0  c=2.05916e-18
c2572 xxwd0|xi1|mm0|bulk 829:wblb0  c=1.22453e-18
c2571 xxwd0|xi1|mm0|bulk 1056:ln_xarr|x_r1c0|n_63  c=3.18017e-17
c2570 xxwd0|xi1|mm0|bulk 1057:ln_xarr|x_r1c0|n_63  c=8.66404e-18
c2569 xxwd0|xi1|mm0|bulk 1048:ln_xarr|x_r0c0|n_63  c=2.80162e-17
c2568 xxwd0|xi1|mm0|bulk 788:wbl1  c=6.28898e-17
c2567 xxwd0|xi1|mm0|bulk 1049:ln_xarr|x_r0c0|n_63  c=9.42915e-18
c2566 xxwd0|xi1|mm0|bulk 789:wbl1  c=2.39801e-18
c2565 xxwd0|xi1|mm0|bulk 783:wbl1  c=3.86022e-18
c2564 xxwd0|xi1|mm0|bulk 567:rbl0  c=9.95796e-19
c2563 xxwd0|xi1|mm0|bulk 826:wblb0  c=1.0349e-18
c2562 xxwd0|xi1|mm0|bulk 815:wblb0  c=1.80321e-18
c2561 xxwd0|xi1|mm0|bulk 816:wblb0  c=1.97606e-18
c2560 xxwd0|xi1|mm0|bulk 625:wwl1  c=4.83062e-18
c2559 xxwd0|xi1|mm0|bulk 677:wwl0  c=4.65311e-18
c2558 xxwd0|xi1|mm0|bulk 858:wbl0  c=1.24732e-18
c2557 xxwd0|xi1|mm0|bulk 620:wwl1  c=7.02306e-18
c2556 xxwd0|xi1|mm0|bulk 1126:ln_xarr|x_r1c1|n_65  c=6.10308e-18
c2555 xxwd0|xi1|mm0|bulk 673:wwl0  c=7.02996e-18
c2554 xxwd0|xi1|mm0|bulk 1133:ln_xarr|x_r1c1|n_63  c=1.18655e-17
c2553 xxwd0|xi1|mm0|bulk 855:wbl0  c=1.25615e-18
c2552 xxwd0|xi1|mm0|bulk 1135:ln_xarr|x_r1c1|n_63  c=1.12351e-17
c2551 xxwd0|xi1|mm0|bulk 573:rbl0  c=5.51121e-17
c2550 xxwd0|xi1|mm0|bulk 718:rbl1  c=3.19429e-17
c2549 xxwd0|xi1|mm0|bulk 827:wblb0  c=1.21868e-18
c2548 xxwd0|xi1|mm0|bulk 713:rbl1  c=5.99841e-18
c2547 xxwd0|xi1|mm0|bulk 818:wblb0  c=2.87519e-20
c2546 xxwd0|xi1|mm0|bulk 427:rwl1  c=2.03661e-18
c2545 xxwd0|xi1|mm0|bulk 828:wblb0  c=5.0173e-18
c2544 xxwd0|xi1|mm0|bulk 912:rwl0  c=1.8863e-18
c2543 xxwd0|xi1|mm0|bulk 1044:xxarr|xi2|net5  c=7.35191e-18
c2542 xxwd0|xi1|mm0|bulk 863:xxarr|xi0|net5  c=6.41408e-18
c2541 xxwd0|xi1|mm0|bulk 853:wbl0  c=7.69645e-19
c2540 xxwd0|xi1|mm0|bulk 852:wbl0  c=1.40194e-18
c2539 xxwd0|xi1|mm0|bulk 851:wbl0  c=1.58246e-18
c2538 xxwd0|xi1|mm0|bulk 591:wwl1  c=2.60832e-17
c2537 xxwd0|xi1|mm0|bulk 825:wblb0  c=1.03743e-17
c2536 xxwd0|xi1|mm0|bulk 392:rwl1  c=2.64273e-17
c2535 xxwd0|xi1|mm0|bulk 867:rwl0  c=2.42928e-17
c2534 xxwd0|xi1|mm0|bulk 641:wwl0  c=2.5066e-17
c2533 xxwd0|xi1|mm0|bulk 568:rbl0  c=3.40088e-19
c2532 xxwd0|xi1|mm0|bulk 566:rbl0  c=5.83008e-19
c2531 xxwd0|xi1|mm0|bulk 572:rbl0  c=2.74077e-17
c2530 xxwd0|xi1|mm0|bulk 570:rbl0  c=3.18895e-17
c2529 xxwd0|xi1|mm0|bulk 426:rwl1  c=5.03699e-19
c2528 xxwd0|xi1|mm0|bulk 571:rbl0  c=1.45216e-17
c2527 xxwd0|xi1|mm0|bulk 420:rwl1  c=5.03699e-19
c2526 xxwd0|xi1|mm0|bulk 832:wblb0  c=5.73873e-17
c2525 xxwd0|xi1|mm0|bulk 831:wblb0  c=2.09967e-18
c2524 xxwd0|xi1|mm0|bulk 1407:ln_xarr|x_r1c0|n_65  c=7.81183e-18
c2523 xxwd0|xi1|mm0|bulk 396:rwl1  c=2.70224e-18
c2522 xxwd0|xi1|mm0|bulk 910:rwl0  c=5.69067e-20
c2521 xxwd0|xi1|mm0|bulk 1053:ln_xarr|x_r1c0|n_63  c=1.02948e-17
c2520 xxwd0|xi1|mm0|bulk 1055:ln_xarr|x_r1c0|n_63  c=1.15598e-17
c2519 xxwd0|xi1|mm0|bulk 909:rwl0  c=3.21937e-19
c2518 xxwd0|xi1|mm0|bulk 901:rwl0  c=3.21937e-19
c2517 xxwd0|xi1|mm0|bulk 824:wblb0  c=3.40844e-18
c2516 xxwd0|xi1|mm0|bulk 876:rwl0  c=2.65544e-18
c2515 xxwd0|xi1|mm0|bulk 592:wwl1  c=9.92396e-19
c2514 xxwd0|xi1|mm0|bulk 622:wwl1  c=4.97047e-19
c2513 xxwd0|xi1|mm0|bulk 593:wwl1  c=2.35104e-18
c2512 xxwd0|xi1|mm0|bulk 642:wwl0  c=9.89346e-19
c2511 xxwd0|xi1|mm0|bulk 672:wwl0  c=9.52646e-19
c2510 xxwd0|xi1|mm0|bulk 643:wwl0  c=7.85953e-18
c2509 xxwd0|xi1|mm0|bulk 776:wbl1  c=3.01975e-18
c2508 xxwd0|xi1|mm0|bulk 856:wbl0  c=6.42651e-18
c2507 xxwd0|xi1|mm0|bulk 806:wblb0  c=2.84938e-18
c2506 xxwd0|xi1|mm0|bulk 857:wbl0  c=5.09607e-18
c2505 xxwd0|xi1|mm0|bulk 1130:ln_xarr|x_r0c1|n_65  c=1.81396e-17
c2504 xxwd0|xi1|mm0|bulk 1121:ln_xarr|x_r0c1|n_63  c=1.22961e-17
c2503 xxwd0|xi1|mm0|bulk 1123:ln_xarr|x_r0c1|n_63  c=1.2185e-17
c2502 xxwd0|xi1|mm0|bulk 833:wblb0  c=1.25375e-19
c2501 xxwd0|xi1|mm0|bulk 859:wbl0  c=4.31858e-17
c2500 xxwd0|xi1|mm0|bulk 860:wbl0  c=1.53249e-18
c2499 xxwd0|xi1|mm0|bulk 854:wbl0  c=2.67452e-18
c2498 xxwd0|xi1|mm0|bulk 1129:ln_xarr|x_r1c1|n_65  c=8.32808e-18
c2497 xxwd0|xi1|mm0|bulk 847:wbl0  c=2.86096e-18
c2496 xxwd0|xi1|mm0|bulk 1127:ln_xarr|x_r1c1|n_65  c=1.19237e-17
c2495 xxwd0|xi1|mm0|bulk 1131:ln_xarr|x_r0c1|n_65  c=7.29141e-18
c2494 xxwd0|xi1|mm0|bulk 626:wwl1  c=4.19401e-18
c2493 xxwd0|xi1|mm0|bulk 1128:ln_xarr|x_r1c1|n_65  c=4.45217e-18
c2492 xxwd0|xi1|mm0|bulk 678:wwl0  c=4.41166e-18
c2491 xxwd0|xi1|mm0|bulk 1132:ln_xarr|x_r0c1|n_65  c=4.45693e-18
c2490 xxwd0|xi1|mm0|bulk 621:wwl1  c=6.78799e-18
c2489 xxwd0|xi1|mm0|bulk 674:wwl0  c=6.79489e-18
c2488 xxwd0|xi1|mm0|bulk 314:ln_xarr|x_r1c1|n_64  c=3.37727e-17
c2487 xxwd0|xi1|mm0|bulk 312:ln_xarr|x_r0c1|n_64  c=3.27781e-17
c2486 xxwd0|xi1|mm0|bulk 714:rbl1  c=3.72442e-18
c2485 xxwd0|xi1|mm0|bulk 313:ln_xarr|x_r1c1|n_64  c=1.4187e-17
c2484 xxwd0|xi1|mm0|bulk 311:ln_xarr|x_r0c1|n_64  c=1.44045e-17
c2483 xxwd0|xi1|mm0|bulk 549:rbl0  c=6.51704e-18
c2482 xxwd0|xi1|mm0|bulk 310:ln_xarr|x_r1c1|n_62  c=1.34213e-17
c2481 xxwd0|xi1|mm0|bulk 308:ln_xarr|x_r1c1|n_62  c=2.68634e-17
c2480 xxwd0|xi1|mm0|bulk 574:rbl0  c=1.78521e-18
c2479 xxwd0|xi1|mm0|bulk 569:rbl0  c=6.58538e-19
c2478 xxwd0|xi1|mm0|bulk 320:ln_xarr|x_r0c1|n_62  c=2.74469e-17
c2477 xxwd0|xi1|mm0|bulk 716:rbl1  c=5.10288e-17
c2476 xxwd0|xi1|mm0|bulk 1050:ln_xarr|x_r0c0|n_65  c=2.338e-17
c2475 xxwd0|xi1|mm0|bulk 701:rbl1  c=3.50328e-18
c2474 xxwd0|xi1|mm0|bulk 318:ln_xarr|x_r0c1|n_62  c=1.33344e-17
c2473 xxwd0|xi1|mm0|bulk 309:ln_xarr|x_r1c1|n_62  c=9.16479e-18
c2472 xxwd0|xi1|mm0|bulk 1045:ln_xarr|x_r0c0|n_63  c=1.09845e-17
c2471 xxwd0|xi1|mm0|bulk 1047:ln_xarr|x_r0c0|n_63  c=1.23543e-17
c2470 xxwd0|xi1|mm0|bulk 319:ln_xarr|x_r0c1|n_62  c=9.16169e-18
c2469 xxwd0|xi1|mm0|bulk 981:ln_xarr|x_r1c1|n_61  c=3.19652e-17
c2468 xxwd0|xi1|mm0|bulk 425:rwl1  c=1.8606e-18
c2467 xxwd0|xi1|mm0|bulk 980:ln_xarr|x_r1c1|n_61  c=9.23114e-18
c2466 xxwd0|xi1|mm0|bulk 911:rwl0  c=1.85497e-18
c2465 xxwd0|xi1|mm0|bulk 979:ln_xarr|x_r1c1|n_61  c=1.10195e-17
c2464 xxwd0|xi1|mm0|bulk 1120:xxarr|xi3|net5  c=7.7725e-18
c2463 xxwd0|xi1|mm0|bulk 978:xxarr|xi1|net5  c=6.41408e-18
c2462 xxwd0|xi1|mm0|bulk 914:ln_xarr|x_r0c1|n_61  c=1.07107e-17
c2461 xxwd0|xi1|mm0|bulk 717:rbl1  c=4.79189e-18
c2460 xxwd0|xi1|mm0|bulk 915:ln_xarr|x_r0c1|n_61  c=9.22671e-18
c2459 xxwd0|xi1|mm0|bulk 418:rwl1  c=1.64851e-19
c2458 xxwd0|xi1|mm0|bulk 913:ln_xarr|x_r0c1|n_61  c=3.18291e-17
c2457 xxwd0|xi1|mm0|bulk 397:rwl1  c=9.20199e-18
c2456 xxwd0|xi1|mm0|bulk 715:rbl1  c=8.79601e-18
c2455 xxwd0|xi1|mm0|bulk 906:rwl0  c=2.12542e-19
c2454 xxwd0|xi1|mm0|bulk xxdec|xn1|mm1|gate  c=7.96747e-19
c2453 xxwd0|xi1|mm0|bulk 880:rwl0  c=1.22803e-17
c2452 xxwd0|xi1|mm0|bulk 704:rbl1  c=5.55548e-19
c2451 xxwd0|xi1|mm0|bulk 1136:ln_xarr|x_r1c1|n_63  c=3.19714e-17
c2450 xxwd0|xi1|mm0|bulk xxdec|xn1|mm0|gate  c=7.39205e-19
c2449 xxwd0|xi1|mm0|bulk 703:rbl1  c=7.78166e-19
c2448 xxwd0|xi1|mm0|bulk 613:wwl1  c=3.11004e-19
c2447 xxwd0|xi1|mm0|bulk 1137:ln_xarr|x_r1c1|n_63  c=1.15242e-17
c2446 xxwd0|xi1|mm0|bulk 702:rbl1  c=2.63086e-19
c2445 xxwd0|xi1|mm0|bulk 663:wwl0  c=7.56661e-19
c2444 xxwd0|xi1|mm0|bulk 1124:ln_xarr|x_r0c1|n_63  c=2.92321e-17
c2443 xxwd0|xi1|mm0|bulk 709:rbl1  c=1.0649e-18
c2442 xxwd0|xi1|mm0|bulk 1125:ln_xarr|x_r0c1|n_63  c=1.13059e-17
c2441 xxwd0|xi1|mm0|bulk 708:rbl1  c=3.63855e-18
c2440 xxwd0|xi1|mm0|bulk 1410:ln_xarr|x_r1c0|n_65  c=1.00318e-17
c2439 xxwd0|xi1|mm0|bulk 1409:ln_xarr|x_r1c0|n_65  c=1.57501e-17
c2438 xxwd0|xi1|mm0|bulk 1051:ln_xarr|x_r0c0|n_65  c=8.54268e-18
c2437 xxwd0|xi1|mm0|bulk 1408:ln_xarr|x_r1c0|n_65  c=4.7461e-18
c2436 xxwd0|xi1|mm0|bulk xxdec|xn2|mm1|gate  c=8.11792e-19
c2435 xxwd0|xi1|mm0|bulk 1052:ln_xarr|x_r0c0|n_65  c=4.75086e-18
c2434 xxwd0|xi1|mm0|bulk xxdec|xn2|mm0|gate  c=7.5566e-19
c2433 xxwd0|xi1|mm0|bulk 307:ln_xarr|x_r1c0|n_64  c=3.56467e-17
c2432 xxwd0|xi1|mm0|bulk 303:ln_xarr|x_r0c0|n_64  c=3.40267e-17
c2431 xxwd0|xi1|mm0|bulk 306:ln_xarr|x_r1c0|n_64  c=1.54528e-17
c2430 xxwd0|xi1|mm0|bulk 302:ln_xarr|x_r0c0|n_64  c=1.53841e-17
c2429 xxwd0|xi1|mm0|bulk 787:wbl1  c=1.11857e-18
cg2428 1420:ln_n_15 0  c=1.9217e-16
c2427 1420:ln_n_15 509:we  c=4.20063e-18
c2426 1420:ln_n_15 510:we  c=3.81368e-18
c2425 1420:ln_n_15 502:we  c=4.27528e-18
c2424 1420:ln_n_15 504:we  c=3.50239e-18
c2423 1420:ln_n_15 507:we  c=4.92662e-18
c2422 1420:ln_n_15 508:we  c=4.37392e-18
c2421 1420:ln_n_15 485:re  c=1.84171e-17
c2420 1420:ln_n_15 486:re  c=1.76051e-17
c2419 1420:ln_n_15 xxdec|xn0|mm1|gate  c=1.2144e-18
c2418 1420:ln_n_15 478:re  c=4.11241e-18
c2417 1420:ln_n_15 481:re  c=3.7747e-18
c2416 1420:ln_n_15 483:re  c=4.24908e-18
c2415 1420:ln_n_15 484:re  c=4.02052e-18
c2414 1420:ln_n_15 461:a  c=3.45146e-17
c2413 1420:ln_n_15 462:a  c=2.55014e-17
c2412 1420:ln_n_15 423:rwl1  c=8.20214e-19
c2411 1420:ln_n_15 460:a  c=1.32574e-17
c2410 1420:ln_n_15 451:a  c=5.41394e-18
c2409 1420:ln_n_15 907:rwl0  c=8.20214e-19
c2408 1420:ln_n_15 456:a  c=3.93776e-18
c2407 1420:ln_n_15 503:we  c=2.14344e-18
c2406 1420:ln_n_15 454:a  c=2.86433e-18
c2405 1420:ln_n_15 505:we  c=1.35398e-18
c2404 1420:ln_n_15 623:wwl1  c=1.0816e-18
c2403 1420:ln_n_15 450:a  c=6.13308e-18
c2402 1420:ln_n_15 506:we  c=3.56563e-17
c2401 1420:ln_n_15 455:a  c=3.28111e-18
c2400 1420:ln_n_15 675:wwl0  c=1.0816e-18
c2399 1420:ln_n_15 487:we  c=3.97844e-18
c2398 1420:ln_n_15 453:a  c=4.34067e-18
c2397 1420:ln_n_15 488:we  c=4.1284e-18
c2396 1420:ln_n_15 1231:xxdec|ab  c=3.40838e-17
c2395 1420:ln_n_15 495:we  c=3.22617e-18
c2394 1420:ln_n_15 1233:xxdec|ab  c=2.5748e-17
c2393 1420:ln_n_15 479:re  c=3.46576e-18
c2392 1420:ln_n_15 1232:xxdec|ab  c=2.10527e-17
c2391 1420:ln_n_15 480:re  c=3.52443e-18
c2390 1420:ln_n_15 1222:xxdec|ab  c=6.20855e-18
c2389 1420:ln_n_15 482:re  c=1.07148e-16
c2388 1420:ln_n_15 1224:xxdec|ab  c=4.01439e-18
c2387 1420:ln_n_15 468:re  c=4.72998e-18
c2386 1420:ln_n_15 1226:xxdec|ab  c=4.83592e-18
c2385 1420:ln_n_15 463:re  c=3.5846e-18
c2384 1420:ln_n_15 1221:xxdec|ab  c=3.77442e-18
c2383 1420:ln_n_15 471:re  c=3.6237e-18
c2382 1420:ln_n_15 1223:xxdec|ab  c=2.24228e-18
c2381 1420:ln_n_15 452:a  c=4.8365e-18
c2380 1420:ln_n_15 1225:xxdec|ab  c=2.79414e-18
c2379 1420:ln_n_15 457:a  c=2.99869e-18
c2378 1420:ln_n_15 458:a  c=1.78907e-18
c2377 1420:ln_n_15 459:a  c=1.27436e-16
c2376 1420:ln_n_15 435:a  c=7.58077e-18
c2375 1420:ln_n_15 428:a  c=7.08057e-18
c2374 1420:ln_n_15 438:a  c=3.72463e-18
c2373 1420:ln_n_15 442:a  c=3.44276e-18
c2372 1420:ln_n_15 1228:xxdec|ab  c=4.30092e-18
c2371 1420:ln_n_15 1229:xxdec|ab  c=3.27891e-18
c2370 1420:ln_n_15 1230:xxdec|ab  c=2.55295e-18
c2369 1420:ln_n_15 1227:xxdec|ab  c=7.91009e-17
c2368 1420:ln_n_15 1202:xxdec|ab  c=6.45138e-18
c2367 1420:ln_n_15 1204:xxdec|ab  c=4.91836e-18
c2366 1420:ln_n_15 1208:xxdec|ab  c=3.82942e-18
cg2365 xxarr|xi3|mra1|bulk 0  c=1.29786e-16
c2364 xxarr|xi3|mra1|bulk 828:wblb0  c=2.32974e-18
c2363 xxarr|xi3|mra1|bulk 822:wblb0  c=1.1454e-18
c2362 xxarr|xi3|mra1|bulk 867:rwl0  c=3.66797e-19
c2361 xxarr|xi3|mra1|bulk 823:wblb0  c=3.38463e-19
c2360 xxarr|xi3|mra1|bulk 641:wwl0  c=6.98078e-19
c2359 xxarr|xi3|mra1|bulk 856:wbl0  c=1.45042e-18
c2358 xxarr|xi3|mra1|bulk 908:rwl0  c=7.18731e-19
c2357 xxarr|xi3|mra1|bulk 676:wwl0  c=1.38913e-18
c2356 xxarr|xi3|mra1|bulk 784:wbl1  c=2.58305e-18
c2355 xxarr|xi3|mra1|bulk 819:wblb0  c=4.35027e-19
c2354 xxarr|xi3|mra1|bulk 1124:ln_xarr|x_r0c1|n_63  c=1.83684e-18
c2353 xxarr|xi3|mra1|bulk 829:wblb0  c=3.30475e-19
c2352 xxarr|xi3|mra1|bulk 820:wblb0  c=2.61601e-19
c2351 xxarr|xi3|mra1|bulk 1048:ln_xarr|x_r0c0|n_63  c=7.40433e-19
c2350 xxarr|xi3|mra1|bulk 573:rbl0  c=1.32839e-18
c2349 xxarr|xi3|mra1|bulk 827:wblb0  c=8.85844e-20
c2348 xxarr|xi3|mra1|bulk 716:rbl1  c=1.32839e-18
cg2347 xxrs1|mmpre|bulk 0  c=5.27324e-17
c2346 xxrs1|mmpre|bulk 542:preb  c=1.72193e-17
c2345 xxrs1|mmpre|bulk 717:rbl1  c=4.12512e-20
c2344 xxrs1|mmpre|bulk 534:preb  c=2.10098e-19
c2343 xxrs1|mmpre|bulk 539:preb  c=3.56628e-18
c2342 xxrs1|mmpre|bulk 350:dout0  c=6.00152e-18
c2341 xxrs1|mmpre|bulk 688:rbl1  c=3.17074e-19
c2340 xxrs1|mmpre|bulk 572:rbl0  c=4.2387e-19
c2339 xxrs1|mmpre|bulk 540:preb  c=4.10908e-18
c2338 xxrs1|mmpre|bulk 357:dout1  c=6.00152e-18
c2337 xxrs1|mmpre|bulk 570:rbl0  c=5.51187e-18
c2336 xxrs1|mmpre|bulk 571:rbl0  c=1.86241e-19
c2335 xxrs1|mmpre|bulk 305:ln_xrs1|n_38  c=4.01384e-17
c2334 xxrs1|mmpre|bulk 538:preb  c=6.76021e-19
c2333 xxrs1|mmpre|bulk 567:rbl0  c=6.85206e-19
c2332 xxrs1|mmpre|bulk 536:preb  c=3.56891e-18
c2331 xxrs1|mmpre|bulk 714:rbl1  c=6.85206e-19
c2330 xxrs1|mmpre|bulk 537:preb  c=1.18843e-18
c2329 xxrs1|mmpre|bulk 515:preb  c=4.10908e-18
c2328 xxrs1|mmpre|bulk 533:preb  c=1.18821e-18
c2327 xxrs1|mmpre|bulk 718:rbl1  c=5.5122e-18
c2326 xxrs1|mmpre|bulk 304:ln_xrs0|n_38  c=3.95841e-17
c2325 xxrs1|mmpre|bulk 574:rbl0  c=4.12512e-20
cg2324 1410:ln_xarr|x_r1c0|n_65 0  c=8.47914e-18
c2323 1410:ln_xarr|x_r1c0|n_65 xxarr|xi2|mra2|drn  c=2.07705e-17
c2322 1410:ln_xarr|x_r1c0|n_65 xxarr|xi2|mra1|drn  c=4.35855e-18
c2321 1410:ln_xarr|x_r1c0|n_65 573:rbl0  c=2.52896e-17
c2320 1410:ln_xarr|x_r1c0|n_65 571:rbl0  c=1.78689e-18
c2319 1410:ln_xarr|x_r1c0|n_65 307:ln_xarr|x_r1c0|n_64  c=1.20404e-17
c2318 1410:ln_xarr|x_r1c0|n_65 1044:xxarr|xi2|net5  c=1.38611e-17
cg2317 1409:ln_xarr|x_r1c0|n_65 0  c=8.35333e-18
c2316 1409:ln_xarr|x_r1c0|n_65 388:rwl1  c=3.82601e-18
c2315 1409:ln_xarr|x_r1c0|n_65 573:rbl0  c=3.51473e-17
c2314 1409:ln_xarr|x_r1c0|n_65 427:rwl1  c=1.44269e-17
c2313 1409:ln_xarr|x_r1c0|n_65 307:ln_xarr|x_r1c0|n_64  c=2.70216e-17
cg2312 1408:ln_xarr|x_r1c0|n_65 0  c=4.32234e-18
c2311 1408:ln_xarr|x_r1c0|n_65 573:rbl0  c=1.71835e-18
c2310 1408:ln_xarr|x_r1c0|n_65 427:rwl1  c=1.13381e-17
c2309 1408:ln_xarr|x_r1c0|n_65 307:ln_xarr|x_r1c0|n_64  c=2.77122e-18
cg2308 1407:ln_xarr|x_r1c0|n_65 0  c=3.83188e-18
c2307 1407:ln_xarr|x_r1c0|n_65 xxarr|xi2|mra1|drn  c=1.61315e-18
c2306 1407:ln_xarr|x_r1c0|n_65 573:rbl0  c=8.37826e-18
c2305 1407:ln_xarr|x_r1c0|n_65 571:rbl0  c=9.90466e-20
c2304 1407:ln_xarr|x_r1c0|n_65 427:rwl1  c=3.18003e-17
c2303 1407:ln_xarr|x_r1c0|n_65 307:ln_xarr|x_r1c0|n_64  c=1.39617e-17
c2302 1407:ln_xarr|x_r1c0|n_65 1044:xxarr|xi2|net5  c=1.11545e-18
cg2301 1402:xxrs1|net7 0  c=1.07173e-17
c2300 1402:xxrs1|net7 688:rbl1  c=3.67382e-19
c2299 1402:xxrs1|net7 357:dout1  c=1.70625e-17
cg2298 1401:xxrs1|net7 0  c=6.90135e-17
c2297 1401:xxrs1|net7 357:dout1  c=4.05019e-20
c2296 1401:xxrs1|net7 714:rbl1  c=7.21998e-17
c2295 1401:xxrs1|net7 717:rbl1  c=1.18855e-18
cg2294 1400:xxrs1|net7 0  c=5.92912e-17
c2293 1400:xxrs1|net7 717:rbl1  c=5.34776e-18
c2292 1400:xxrs1|net7 357:dout1  c=5.24128e-18
cg2291 1399:xxrs1|net7 0  c=4.28241e-16
c2290 1399:xxrs1|net7 714:rbl1  c=1.10203e-17
c2289 1399:xxrs1|net7 717:rbl1  c=1.19171e-18
c2288 1399:xxrs1|net7 xxrs1|xis2|mm0|drn  c=4.8157e-17
c2287 1399:xxrs1|net7 xxrs1|xis2|mm1|drn  c=1.35765e-16
c2286 1399:xxrs1|net7 357:dout1  c=1.2277e-16
c2285 1399:xxrs1|net7 718:rbl1  c=2.51411e-18
cg2284 1398:xxrs1|net7 0  c=1.59964e-18
c2283 1398:xxrs1|net7 357:dout1  c=1.27986e-23
c2282 1398:xxrs1|net7 717:rbl1  c=9.71363e-18
c2281 1398:xxrs1|net7 xxrs1|xis1|mm0|gate  c=6.95665e-19
c2280 1398:xxrs1|net7 714:rbl1  c=1.89603e-17
c2279 1398:xxrs1|net7 688:rbl1  c=6.67865e-20
cg2278 1397:xxrs1|net7 0  c=2.96355e-17
c2277 1397:xxrs1|net7 357:dout1  c=2.05065e-19
c2276 1397:xxrs1|net7 717:rbl1  c=1.84681e-17
c2275 1397:xxrs1|net7 xxrs1|xis1|mm0|gate  c=4.369e-19
c2274 1397:xxrs1|net7 714:rbl1  c=2.5968e-17
c2273 1397:xxrs1|net7 688:rbl1  c=3.77421e-19
cg2272 1396:xxrs1|net7 0  c=1.36127e-17
c2271 1396:xxrs1|net7 357:dout1  c=2.21775e-18
cg2270 1395:xxrs1|net7 0  c=1.54782e-17
c2269 1395:xxrs1|net7 357:dout1  c=2.22031e-18
cg2268 1393:xxrs1|net7 0  c=7.22226e-18
c2267 1393:xxrs1|net7 717:rbl1  c=2.56825e-18
cg2266 1392:xxrs1|net7 0  c=1.03295e-17
c2265 1392:xxrs1|net7 717:rbl1  c=2.61917e-18
cg2264 xxrs1|xis1|mm0|drn 0  c=2.12421e-17
c2263 xxrs1|xis1|mm0|drn 715:rbl1  c=8.86608e-20
c2262 xxrs1|xis1|mm0|drn 714:rbl1  c=4.73993e-17
cg2261 xxrs1|xis1|mm1|drn 0  c=5.35623e-17
c2260 xxrs1|xis1|mm1|drn 714:rbl1  c=1.35765e-16
cg2259 xxrs1|xis2|mm1|gate 0  c=2.4949e-17
c2258 xxrs1|xis2|mm1|gate 357:dout1  c=1.00546e-18
c2257 xxrs1|xis2|mm1|gate 714:rbl1  c=1.82431e-18
cg2256 xxrs1|xis2|mm0|gate 0  c=4.67919e-18
c2255 xxrs1|xis2|mm0|gate 357:dout1  c=8.91257e-19
c2254 xxrs1|xis2|mm0|gate 714:rbl1  c=6.34544e-19
cg2253 1378:xxrs0|net7 0  c=1.24563e-17
c2252 1378:xxrs0|net7 572:rbl0  c=3.67382e-19
c2251 1378:xxrs0|net7 350:dout0  c=1.70625e-17
c2250 1378:xxrs0|net7 xxrs0|xis2|mm1|drn  c=6.80695e-21
cg2249 1377:xxrs0|net7 0  c=6.96913e-17
c2248 1377:xxrs0|net7 574:rbl0  c=1.18855e-18
c2247 1377:xxrs0|net7 567:rbl0  c=7.07144e-17
c2246 1377:xxrs0|net7 350:dout0  c=4.05019e-20
c2245 1377:xxrs0|net7 xxrs0|xis1|mm1|gate  c=1.58159e-17
cg2244 1376:xxrs0|net7 0  c=1.36028e-17
c2243 1376:xxrs0|net7 350:dout0  c=2.21775e-18
cg2242 1375:xxrs0|net7 0  c=6.13148e-17
c2241 1375:xxrs0|net7 350:dout0  c=5.24128e-18
c2240 1375:xxrs0|net7 574:rbl0  c=5.2524e-18
cg2239 1374:xxrs0|net7 0  c=7.15357e-18
c2238 1374:xxrs0|net7 574:rbl0  c=2.45977e-18
cg2237 1373:xxrs0|net7 0  c=1.54668e-17
c2236 1373:xxrs0|net7 350:dout0  c=2.22031e-18
cg2235 1372:xxrs0|net7 0  c=1.82676e-18
c2234 1372:xxrs0|net7 574:rbl0  c=9.71363e-18
c2233 1372:xxrs0|net7 350:dout0  c=1.27986e-23
c2232 1372:xxrs0|net7 567:rbl0  c=1.89603e-17
c2231 1372:xxrs0|net7 xxrs0|xis1|mm0|gate  c=6.68309e-19
cg2230 1371:xxrs0|net7 0  c=2.87492e-17
c2229 1371:xxrs0|net7 574:rbl0  c=1.84681e-17
c2228 1371:xxrs0|net7 350:dout0  c=2.05065e-19
c2227 1371:xxrs0|net7 567:rbl0  c=2.5968e-17
c2226 1371:xxrs0|net7 xxrs0|xis1|mm0|gate  c=4.20867e-18
cg2225 1370:xxrs0|net7 0  c=4.22561e-16
c2224 1370:xxrs0|net7 xxrs0|xis1|mm0|gate  c=6.34544e-19
c2223 1370:xxrs0|net7 xxrs0|xis1|mm1|gate  c=1.82431e-18
c2222 1370:xxrs0|net7 350:dout0  c=1.2277e-16
c2221 1370:xxrs0|net7 574:rbl0  c=1.19171e-18
c2220 1370:xxrs0|net7 567:rbl0  c=1.10203e-17
c2219 1370:xxrs0|net7 xxrs0|xis2|mm0|drn  c=4.8157e-17
c2218 1370:xxrs0|net7 xxrs0|xis2|mm1|drn  c=1.35765e-16
c2217 1370:xxrs0|net7 570:rbl0  c=2.51411e-18
cg2216 1369:xxrs0|net7 0  c=1.07833e-17
c2215 1369:xxrs0|net7 574:rbl0  c=2.51069e-18
cg2214 xxrs0|xis1|mm0|drn 0  c=2.11615e-17
c2213 xxrs0|xis1|mm0|drn 569:rbl0  c=1.07838e-19
c2212 xxrs0|xis1|mm0|drn 567:rbl0  c=4.73993e-17
cg2211 xxrs0|xis1|mm1|drn 0  c=5.35623e-17
c2210 xxrs0|xis1|mm1|drn 567:rbl0  c=1.35765e-16
cg2209 xxrs0|xis2|mm1|gate 0  c=1.06624e-17
c2208 xxrs0|xis2|mm1|gate 350:dout0  c=1.82636e-17
cg2207 xxrs0|xis2|mm0|gate 0  c=3.63147e-18
c2206 xxrs0|xis2|mm0|gate 350:dout0  c=6.74797e-18
cg2205 1354:xxdec|xn3|net18 0  c=4.16015e-17
c2204 1354:xxdec|xn3|net18 1336:xxdec|net20  c=1.24093e-18
c2203 1354:xxdec|xn3|net18 xxdec|xn3|mm1|gate  c=2.25306e-17
c2202 1354:xxdec|xn3|net18 1340:xxdec|net20  c=7.88159e-18
c2201 1354:xxdec|xn3|net18 xxdec|xn3|mm0|gate  c=3.45718e-17
c2200 1354:xxdec|xn3|net18 xxdec|xn3|mm3|gate  c=2.41729e-20
c2199 1354:xxdec|xn3|net18 1317:xxdec|net20  c=1.13654e-17
c2198 1354:xxdec|xn3|net18 xxdec|xn3|mm2|gate  c=2.41729e-20
c2197 1354:xxdec|xn3|net18 xxdec|xn3|mm2|drn  c=1.64893e-19
c2196 1354:xxdec|xn3|net18 1341:xxdec|net20  c=2.6779e-17
cg2195 xxdec|xn3|mm0|drn 0  c=1.23528e-17
c2194 xxdec|xn3|mm0|drn 1341:xxdec|net20  c=4.69934e-18
c2193 xxdec|xn3|mm0|drn xxdec|xn3|mm0|gate  c=2.87304e-17
c2192 xxdec|xn3|mm0|drn xxdec|xn3|mm1|gate  c=1.24771e-17
c2191 xxdec|xn3|mm0|drn xxdec|xn3|mm2|drn  c=8.90954e-18
c2190 xxdec|xn3|mm0|drn xxdec|xn3|mm1|drn  c=9.26387e-18
cg2189 1352:xxdec|xn2|net18 0  c=3.92296e-17
c2188 1352:xxdec|xn2|net18 xxdec|xn2|mm2|drn  c=4.28722e-19
c2187 1352:xxdec|xn2|net18 1309:xxdec|net15  c=1.24093e-18
c2186 1352:xxdec|xn2|net18 1313:xxdec|net15  c=7.88159e-18
c2185 1352:xxdec|xn2|net18 1291:xxdec|net15  c=1.13653e-17
c2184 1352:xxdec|xn2|net18 1314:xxdec|net15  c=2.66919e-17
c2183 1352:xxdec|xn2|net18 xxdec|xn2|mm1|gate  c=2.25312e-17
c2182 1352:xxdec|xn2|net18 xxdec|xn2|mm0|gate  c=3.45908e-17
c2181 1352:xxdec|xn2|net18 xxdec|xn2|mm3|gate  c=2.41729e-20
c2180 1352:xxdec|xn2|net18 xxdec|xn2|mm2|gate  c=2.41729e-20
cg2179 xxdec|xn2|mm0|drn 0  c=1.02576e-17
c2178 xxdec|xn2|mm0|drn 1314:xxdec|net15  c=7.7708e-18
c2177 xxdec|xn2|mm0|drn xxdec|xn2|mm0|gate  c=2.87304e-17
c2176 xxdec|xn2|mm0|drn xxdec|xn2|mm1|gate  c=1.24771e-17
c2175 xxdec|xn2|mm0|drn xxdec|xn2|mm2|drn  c=4.88881e-18
c2174 xxdec|xn2|mm0|drn xxdec|xn2|mm1|drn  c=9.26387e-18
cg2173 1350:xxdec|xn1|net18 0  c=3.98199e-17
c2172 1350:xxdec|xn1|net18 xxdec|xn1|mm1|gate  c=2.25312e-17
c2171 1350:xxdec|xn1|net18 1282:xxdec|net10  c=1.24093e-18
c2170 1350:xxdec|xn1|net18 xxdec|xn1|mm0|gate  c=3.45908e-17
c2169 1350:xxdec|xn1|net18 xxdec|xn1|mm3|gate  c=2.41729e-20
c2168 1350:xxdec|xn1|net18 xxdec|xn1|mm2|gate  c=2.41729e-20
c2167 1350:xxdec|xn1|net18 xxdec|xn1|mm2|drn  c=4.28722e-19
c2166 1350:xxdec|xn1|net18 1286:xxdec|net10  c=7.88159e-18
c2165 1350:xxdec|xn1|net18 1264:xxdec|net10  c=1.13653e-17
c2164 1350:xxdec|xn1|net18 1287:xxdec|net10  c=2.66919e-17
cg2163 xxdec|xn1|mm0|drn 0  c=9.91856e-18
c2162 xxdec|xn1|mm0|drn 1287:xxdec|net10  c=7.7708e-18
c2161 xxdec|xn1|mm0|drn xxdec|xn1|mm0|gate  c=2.87304e-17
c2160 xxdec|xn1|mm0|drn xxdec|xn1|mm1|gate  c=1.24771e-17
c2159 xxdec|xn1|mm0|drn xxdec|xn1|mm2|drn  c=4.88881e-18
c2158 xxdec|xn1|mm0|drn xxdec|xn1|mm1|drn  c=9.26387e-18
cg2157 1348:xxdec|xn0|net18 0  c=4.06566e-17
c2156 1348:xxdec|xn0|net18 1232:xxdec|ab  c=6.06032e-19
c2155 1348:xxdec|xn0|net18 1255:xxdec|net5  c=1.24093e-18
c2154 1348:xxdec|xn0|net18 1259:xxdec|net5  c=7.88159e-18
c2153 1348:xxdec|xn0|net18 xxdec|xn0|mm1|gate  c=2.9179e-17
c2152 1348:xxdec|xn0|net18 xxdec|xn0|mm0|gate  c=3.45908e-17
c2151 1348:xxdec|xn0|net18 xxdec|xn0|mm3|gate  c=2.41729e-20
c2150 1348:xxdec|xn0|net18 1250:xxdec|net5  c=1.13653e-17
c2149 1348:xxdec|xn0|net18 xxdec|xn0|mm2|gate  c=2.41729e-20
c2148 1348:xxdec|xn0|net18 xxdec|xn0|mm2|drn  c=4.28722e-19
c2147 1348:xxdec|xn0|net18 1260:xxdec|net5  c=2.66919e-17
cg2146 xxdec|xn0|mm0|drn 0  c=9.91856e-18
c2145 xxdec|xn0|mm0|drn 1260:xxdec|net5  c=7.7708e-18
c2144 xxdec|xn0|mm0|drn xxdec|xn0|mm0|gate  c=2.87304e-17
c2143 xxdec|xn0|mm0|drn xxdec|xn0|mm1|gate  c=2.87304e-17
c2142 xxdec|xn0|mm0|drn xxdec|xn0|mm2|drn  c=4.88881e-18
c2141 xxdec|xn0|mm0|drn xxdec|xn0|mm1|drn  c=9.26387e-18
c2140 1341:xxdec|net20 397:rwl1  c=3.12109e-21
c2139 1341:xxdec|net20 xxdec|xn3|mm1|gate  c=1.44626e-17
c2138 1341:xxdec|net20 xxdec|xn3|mm0|gate  c=1.66429e-17
c2137 1341:xxdec|net20 xxdec|xn3|mm3|gate  c=4.90757e-19
c2136 1341:xxdec|net20 485:re  c=8.60782e-18
c2135 1341:xxdec|net20 xxdec|xn3|mm2|gate  c=4.90757e-19
c2134 1341:xxdec|net20 461:a  c=6.5507e-18
cg2133 1340:xxdec|net20 0  c=2.91483e-17
c2132 1340:xxdec|net20 461:a  c=1.60319e-19
c2131 1340:xxdec|net20 xxdec|xn3|mm1|gate  c=2.78023e-17
c2130 1340:xxdec|net20 397:rwl1  c=1.68576e-18
c2129 1340:xxdec|net20 423:rwl1  c=1.18286e-20
cg2128 1339:xxdec|net20 0  c=6.71382e-17
c2127 1339:xxdec|net20 461:a  c=7.4455e-18
c2126 1339:xxdec|net20 397:rwl1  c=3.52979e-19
c2125 1339:xxdec|net20 423:rwl1  c=5.30503e-18
cg2124 1338:xxdec|net20 0  c=1.07007e-17
c2123 1338:xxdec|net20 461:a  c=1.7918e-23
c2122 1338:xxdec|net20 xxdec|xn3|mm1|gate  c=2.30741e-19
c2121 1338:xxdec|net20 xxdec|xi4|mm0|drn  c=2.57172e-21
c2120 1338:xxdec|net20 397:rwl1  c=1.59028e-18
c2119 1338:xxdec|net20 422:rwl1  c=2.32964e-19
c2118 1338:xxdec|net20 423:rwl1  c=1.73802e-17
cg2117 1337:xxdec|net20 0  c=1.56353e-17
c2116 1337:xxdec|net20 423:rwl1  c=2.27092e-18
cg2115 1336:xxdec|net20 0  c=2.96158e-17
c2114 1336:xxdec|net20 423:rwl1  c=2.25482e-20
c2113 1336:xxdec|net20 xxdec|xn3|mm1|gate  c=3.26529e-17
c2112 1336:xxdec|net20 xxdec|xn3|mm0|gate  c=5.10608e-17
c2111 1336:xxdec|net20 xxdec|xn3|mm3|gate  c=3.75485e-19
c2110 1336:xxdec|net20 485:re  c=5.16397e-17
c2109 1336:xxdec|net20 xxdec|xn3|mm2|gate  c=1.54197e-17
c2108 1336:xxdec|net20 459:a  c=2.17348e-19
c2107 1336:xxdec|net20 461:a  c=5.12315e-17
cg2106 1333:xxdec|net20 0  c=1.66544e-17
c2105 1333:xxdec|net20 461:a  c=5.95337e-18
c2104 1333:xxdec|net20 423:rwl1  c=2.5523e-23
c2103 1333:xxdec|net20 xxdec|xn3|mm3|gate  c=4.13101e-19
c2102 1333:xxdec|net20 xxdec|xn3|mm1|gate  c=2.28843e-17
c2101 1333:xxdec|net20 397:rwl1  c=1.28575e-19
cg2100 1319:xxdec|net20 0  c=1.36345e-17
c2099 1319:xxdec|net20 461:a  c=1.20248e-20
c2098 1319:xxdec|net20 423:rwl1  c=2.27653e-18
cg2097 1317:xxdec|net20 0  c=2.70357e-17
c2096 1317:xxdec|net20 397:rwl1  c=1.74302e-19
c2095 1317:xxdec|net20 485:re  c=1.13594e-17
c2094 1317:xxdec|net20 461:a  c=7.37216e-17
c2093 1317:xxdec|net20 451:a  c=3.83309e-20
cg2092 xxdec|xn3|mm2|drn 0  c=5.25373e-17
c2091 xxdec|xn3|mm2|drn xxdec|xn3|mm0|gate  c=8.09586e-17
c2090 xxdec|xn3|mm2|drn xxdec|xn3|mm1|gate  c=3.30727e-17
cg2089 xxdec|xn3|mm1|drn 0  c=2.07409e-17
c2088 xxdec|xn3|mm1|drn xxdec|xn3|mm1|gate  c=4.81277e-17
c2087 xxdec|xi4|mm1|gate 423:rwl1  c=1.80051e-17
cg2086 xxdec|xi4|mm0|gate 0  c=4.18777e-16
c2085 xxdec|xi4|mm0|gate 423:rwl1  c=1.31698e-16
c2084 xxdec|xi4|mm0|gate 422:rwl1  c=8.90575e-19
c2083 xxdec|xi4|mm0|gate 397:rwl1  c=2.56154e-18
c2082 xxdec|xi4|mm0|gate xxdec|xi4|mm0|drn  c=4.81166e-17
c2081 xxdec|xi4|mm0|gate xxdec|xi4|mm1|drn  c=1.3547e-16
c2080 xxdec|xi4|mm0|gate xxdec|xn3|mm1|gate  c=1.16642e-17
c2079 xxdec|xi4|mm0|gate xxdec|xn3|mm3|gate  c=1.80865e-18
c2078 xxdec|xi4|mm0|gate 461:a  c=2.83021e-18
c2077 1314:xxdec|net15 1231:xxdec|ab  c=6.5507e-18
c2076 1314:xxdec|net15 880:rwl0  c=3.12109e-21
c2075 1314:xxdec|net15 486:re  c=8.60782e-18
c2074 1314:xxdec|net15 xxdec|xn2|mm1|gate  c=1.44626e-17
c2073 1314:xxdec|net15 xxdec|xn2|mm0|gate  c=1.66429e-17
c2072 1314:xxdec|net15 xxdec|xn2|mm3|gate  c=4.90757e-19
c2071 1314:xxdec|net15 xxdec|xn2|mm2|gate  c=4.90757e-19
cg2070 1313:xxdec|net15 0  c=2.93856e-17
c2069 1313:xxdec|net15 1231:xxdec|ab  c=1.60319e-19
c2068 1313:xxdec|net15 xxdec|xn2|mm1|gate  c=2.78023e-17
c2067 1313:xxdec|net15 880:rwl0  c=1.55568e-18
c2066 1313:xxdec|net15 907:rwl0  c=1.18286e-20
cg2065 1312:xxdec|net15 0  c=6.65333e-17
c2064 1312:xxdec|net15 907:rwl0  c=5.53922e-18
c2063 1312:xxdec|net15 1231:xxdec|ab  c=7.4455e-18
c2062 1312:xxdec|net15 880:rwl0  c=3.52979e-19
c2061 1312:xxdec|net15 485:re  c=3.14212e-19
cg2060 1311:xxdec|net15 0  c=1.02057e-17
c2059 1311:xxdec|net15 907:rwl0  c=1.73133e-17
c2058 1311:xxdec|net15 1231:xxdec|ab  c=1.7918e-23
c2057 1311:xxdec|net15 898:rwl0  c=1.77551e-19
c2056 1311:xxdec|net15 880:rwl0  c=1.30265e-18
c2055 1311:xxdec|net15 xxdec|xn3|mm0|gate  c=4.25254e-19
c2054 1311:xxdec|net15 485:re  c=2.85835e-23
c2053 1311:xxdec|net15 xxdec|xn2|mm1|gate  c=2.30741e-19
c2052 1311:xxdec|net15 xxdec|xi3|mm0|drn  c=2.57172e-21
cg2051 1310:xxdec|net15 0  c=1.48995e-17
c2050 1310:xxdec|net15 907:rwl0  c=2.54032e-18
cg2049 1309:xxdec|net15 0  c=2.96158e-17
c2048 1309:xxdec|net15 907:rwl0  c=2.25482e-20
c2047 1309:xxdec|net15 1231:xxdec|ab  c=5.12315e-17
c2046 1309:xxdec|net15 486:re  c=5.16397e-17
c2045 1309:xxdec|net15 xxdec|xn2|mm1|gate  c=3.26529e-17
c2044 1309:xxdec|net15 xxdec|xn2|mm0|gate  c=5.10608e-17
c2043 1309:xxdec|net15 xxdec|xn2|mm3|gate  c=3.75485e-19
c2042 1309:xxdec|net15 xxdec|xn2|mm2|gate  c=1.54197e-17
cg2041 1306:xxdec|net15 0  c=1.66544e-17
c2040 1306:xxdec|net15 1231:xxdec|ab  c=5.95337e-18
c2039 1306:xxdec|net15 907:rwl0  c=2.5523e-23
c2038 1306:xxdec|net15 xxdec|xn2|mm3|gate  c=4.13101e-19
c2037 1306:xxdec|net15 xxdec|xn2|mm1|gate  c=2.28843e-17
c2036 1306:xxdec|net15 880:rwl0  c=8.8475e-20
cg2035 1291:xxdec|net15 0  c=2.70357e-17
c2034 1291:xxdec|net15 1231:xxdec|ab  c=7.37216e-17
c2033 1291:xxdec|net15 1222:xxdec|ab  c=3.83309e-20
c2032 1291:xxdec|net15 880:rwl0  c=1.74302e-19
c2031 1291:xxdec|net15 486:re  c=1.13594e-17
cg2030 1290:xxdec|net15 0  c=1.28988e-17
c2029 1290:xxdec|net15 907:rwl0  c=2.54593e-18
c2028 1290:xxdec|net15 1231:xxdec|ab  c=1.20248e-20
c2027 1290:xxdec|net15 485:re  c=8.16761e-21
cg2026 xxdec|xn2|mm2|drn 0  c=5.14389e-17
c2025 xxdec|xn2|mm2|drn 1222:xxdec|ab  c=9.58238e-20
c2024 xxdec|xn2|mm2|drn 481:re  c=9.58238e-20
c2023 xxdec|xn2|mm2|drn xxdec|xn2|mm1|gate  c=3.30727e-17
c2022 xxdec|xn2|mm2|drn xxdec|xn2|mm0|gate  c=8.09586e-17
cg2021 xxdec|xn2|mm1|drn 0  c=1.55185e-17
c2020 xxdec|xn2|mm1|drn 880:rwl0  c=1.00511e-18
c2019 xxdec|xn2|mm1|drn xxdec|xn2|mm1|gate  c=4.81277e-17
c2018 xxdec|xi3|mm1|gate 907:rwl0  c=1.84108e-17
c2017 xxdec|xi3|mm1|gate xxdec|xn3|mm0|gate  c=1.82431e-18
cg2016 xxdec|xi3|mm0|gate 0  c=4.11746e-16
c2015 xxdec|xi3|mm0|gate 907:rwl0  c=1.31757e-16
c2014 xxdec|xi3|mm0|gate 1231:xxdec|ab  c=2.83021e-18
c2013 xxdec|xi3|mm0|gate 898:rwl0  c=9.95834e-19
c2012 xxdec|xi3|mm0|gate 880:rwl0  c=4.29343e-18
c2011 xxdec|xi3|mm0|gate xxdec|xn3|mm0|gate  c=9.0485e-18
c2010 xxdec|xi3|mm0|gate 482:re  c=5.23095e-19
c2009 xxdec|xi3|mm0|gate 485:re  c=3.09519e-18
c2008 xxdec|xi3|mm0|gate xxdec|xn2|mm1|gate  c=1.16642e-17
c2007 xxdec|xi3|mm0|gate xxdec|xi3|mm0|drn  c=4.82168e-17
c2006 xxdec|xi3|mm0|gate xxdec|xi3|mm1|drn  c=1.35765e-16
c2005 xxdec|xi3|mm0|gate xxdec|xn2|mm3|gate  c=1.80865e-18
c2004 1287:xxdec|net10 xxdec|xn1|mm1|gate  c=1.44626e-17
c2003 1287:xxdec|net10 xxdec|xn1|mm0|gate  c=1.66429e-17
c2002 1287:xxdec|net10 xxdec|xn1|mm3|gate  c=4.90757e-19
c2001 1287:xxdec|net10 509:we  c=8.60782e-18
c2000 1287:xxdec|net10 xxdec|xn1|mm2|gate  c=4.90757e-19
c1999 1287:xxdec|net10 462:a  c=6.5507e-18
cg1998 1286:xxdec|net10 0  c=3.0588e-17
c1997 1286:xxdec|net10 462:a  c=1.60319e-19
c1996 1286:xxdec|net10 xxdec|xn1|mm1|gate  c=2.78023e-17
c1995 1286:xxdec|net10 623:wwl1  c=1.18286e-20
cg1994 1285:xxdec|net10 0  c=6.71957e-17
c1993 1285:xxdec|net10 623:wwl1  c=5.53922e-18
c1992 1285:xxdec|net10 462:a  c=7.4455e-18
cg1991 1284:xxdec|net10 0  c=1.17757e-17
c1990 1284:xxdec|net10 623:wwl1  c=1.73133e-17
c1989 1284:xxdec|net10 xxdec|xn1|mm1|gate  c=2.30741e-19
c1988 1284:xxdec|net10 613:wwl1  c=1.27916e-19
c1987 1284:xxdec|net10 xxdec|xi2|mm0|drn  c=2.57172e-21
c1986 1284:xxdec|net10 462:a  c=1.7918e-23
cg1985 1283:xxdec|net10 0  c=1.48995e-17
c1984 1283:xxdec|net10 623:wwl1  c=2.54032e-18
cg1983 1282:xxdec|net10 0  c=2.9687e-17
c1982 1282:xxdec|net10 623:wwl1  c=2.25482e-20
c1981 1282:xxdec|net10 xxdec|xn1|mm1|gate  c=3.26529e-17
c1980 1282:xxdec|net10 xxdec|xn1|mm0|gate  c=5.10608e-17
c1979 1282:xxdec|net10 xxdec|xn1|mm3|gate  c=3.75485e-19
c1978 1282:xxdec|net10 509:we  c=5.16397e-17
c1977 1282:xxdec|net10 xxdec|xn1|mm2|gate  c=1.54197e-17
c1976 1282:xxdec|net10 462:a  c=5.12315e-17
cg1975 1279:xxdec|net10 0  c=1.68764e-17
c1974 1279:xxdec|net10 623:wwl1  c=2.5523e-23
c1973 1279:xxdec|net10 xxdec|xn1|mm1|gate  c=2.28843e-17
c1972 1279:xxdec|net10 xxdec|xn1|mm3|gate  c=4.13101e-19
c1971 1279:xxdec|net10 462:a  c=5.95337e-18
cg1970 1264:xxdec|net10 0  c=2.72417e-17
c1969 1264:xxdec|net10 503:we  c=5.40969e-20
c1968 1264:xxdec|net10 509:we  c=1.13594e-17
c1967 1264:xxdec|net10 462:a  c=7.37197e-17
c1966 1264:xxdec|net10 456:a  c=3.83309e-20
cg1965 1263:xxdec|net10 0  c=1.2907e-17
c1964 1263:xxdec|net10 623:wwl1  c=2.54593e-18
c1963 1263:xxdec|net10 462:a  c=1.20248e-20
cg1962 xxdec|xn1|mm2|drn 0  c=5.14389e-17
c1961 xxdec|xn1|mm2|drn xxdec|xn1|mm1|gate  c=3.30727e-17
c1960 xxdec|xn1|mm2|drn xxdec|xn1|mm0|gate  c=8.09586e-17
c1959 xxdec|xn1|mm2|drn 502:we  c=1.04316e-19
c1958 xxdec|xn1|mm2|drn 456:a  c=9.58238e-20
cg1957 xxdec|xn1|mm1|drn 0  c=1.66921e-17
c1956 xxdec|xn1|mm1|drn xxdec|xn1|mm1|gate  c=4.81277e-17
cg1955 xxdec|xi2|mm1|gate 0  c=1.82431e-18
c1954 xxdec|xi2|mm1|gate 623:wwl1  c=1.83156e-17
cg1953 xxdec|xi2|mm0|gate 0  c=4.2822e-16
c1952 xxdec|xi2|mm0|gate 623:wwl1  c=1.31549e-16
c1951 xxdec|xi2|mm0|gate xxdec|xn1|mm1|gate  c=1.16642e-17
c1950 xxdec|xi2|mm0|gate xxdec|xn1|mm3|gate  c=1.80865e-18
c1949 xxdec|xi2|mm0|gate 613:wwl1  c=1.01379e-18
c1948 xxdec|xi2|mm0|gate xxdec|xi2|mm0|drn  c=4.82168e-17
c1947 xxdec|xi2|mm0|gate xxdec|xi2|mm1|drn  c=1.35765e-16
c1946 xxdec|xi2|mm0|gate 462:a  c=2.83021e-18
c1945 1260:xxdec|net5 1233:xxdec|ab  c=6.5507e-18
c1944 1260:xxdec|net5 1232:xxdec|ab  c=3.31803e-19
c1943 1260:xxdec|net5 510:we  c=8.60782e-18
c1942 1260:xxdec|net5 xxdec|xn0|mm1|gate  c=1.44626e-17
c1941 1260:xxdec|net5 xxdec|xn0|mm0|gate  c=1.66429e-17
c1940 1260:xxdec|net5 xxdec|xn0|mm3|gate  c=4.90757e-19
c1939 1260:xxdec|net5 xxdec|xn0|mm2|gate  c=4.90757e-19
cg1938 1259:xxdec|net5 0  c=3.24024e-17
c1937 1259:xxdec|net5 1233:xxdec|ab  c=1.60319e-19
c1936 1259:xxdec|net5 xxdec|xn0|mm1|gate  c=2.78023e-17
c1935 1259:xxdec|net5 675:wwl0  c=1.18286e-20
cg1934 1258:xxdec|net5 0  c=6.65283e-17
c1933 1258:xxdec|net5 1233:xxdec|ab  c=7.4455e-18
c1932 1258:xxdec|net5 509:we  c=3.14212e-19
c1931 1258:xxdec|net5 675:wwl0  c=5.53922e-18
cg1930 1257:xxdec|net5 0  c=1.3094e-17
c1929 1257:xxdec|net5 1233:xxdec|ab  c=1.7918e-23
c1928 1257:xxdec|net5 509:we  c=2.85835e-23
c1927 1257:xxdec|net5 xxdec|xn0|mm1|gate  c=2.30741e-19
c1926 1257:xxdec|net5 663:wwl0  c=8.44845e-20
c1925 1257:xxdec|net5 xxdec|xn1|mm0|gate  c=4.25254e-19
c1924 1257:xxdec|net5 675:wwl0  c=1.73133e-17
c1923 1257:xxdec|net5 xxdec|xi1|mm0|drn  c=2.57172e-21
cg1922 1256:xxdec|net5 0  c=1.49663e-17
c1921 1256:xxdec|net5 675:wwl0  c=2.54032e-18
cg1920 1255:xxdec|net5 0  c=2.95842e-17
c1919 1255:xxdec|net5 1233:xxdec|ab  c=5.12315e-17
c1918 1255:xxdec|net5 1232:xxdec|ab  c=7.11124e-20
c1917 1255:xxdec|net5 506:we  c=2.19448e-19
c1916 1255:xxdec|net5 675:wwl0  c=2.25482e-20
c1915 1255:xxdec|net5 510:we  c=5.16397e-17
c1914 1255:xxdec|net5 xxdec|xn0|mm1|gate  c=5.06002e-17
c1913 1255:xxdec|net5 xxdec|xn0|mm0|gate  c=5.10608e-17
c1912 1255:xxdec|net5 xxdec|xn0|mm3|gate  c=3.75485e-19
c1911 1255:xxdec|net5 xxdec|xn0|mm2|gate  c=1.54197e-17
cg1910 1252:xxdec|net5 0  c=1.69812e-17
c1909 1252:xxdec|net5 1233:xxdec|ab  c=5.95337e-18
c1908 1252:xxdec|net5 675:wwl0  c=2.5523e-23
c1907 1252:xxdec|net5 xxdec|xn0|mm3|gate  c=4.13101e-19
c1906 1252:xxdec|net5 xxdec|xn0|mm1|gate  c=2.28843e-17
cg1905 1250:xxdec|net5 0  c=2.54179e-17
c1904 1250:xxdec|net5 1233:xxdec|ab  c=7.37197e-17
c1903 1250:xxdec|net5 1232:xxdec|ab  c=3.42877e-20
c1902 1250:xxdec|net5 510:we  c=1.15353e-17
c1901 1250:xxdec|net5 1224:xxdec|ab  c=3.83309e-20
c1900 1250:xxdec|net5 505:we  c=5.40969e-20
cg1899 1236:xxdec|net5 0  c=1.29596e-17
c1898 1236:xxdec|net5 1233:xxdec|ab  c=1.20248e-20
c1897 1236:xxdec|net5 675:wwl0  c=2.54593e-18
c1896 1236:xxdec|net5 509:we  c=8.16761e-21
cg1895 xxdec|xn0|mm2|drn 0  c=5.14389e-17
c1894 xxdec|xn0|mm2|drn 1224:xxdec|ab  c=9.58238e-20
c1893 xxdec|xn0|mm2|drn 504:we  c=1.04316e-19
c1892 xxdec|xn0|mm2|drn xxdec|xn0|mm1|gate  c=8.09586e-17
c1891 xxdec|xn0|mm2|drn xxdec|xn0|mm0|gate  c=8.09586e-17
cg1890 xxdec|xn0|mm1|drn 0  c=1.62697e-17
c1889 xxdec|xn0|mm1|drn xxdec|xn0|mm1|gate  c=4.81277e-17
c1888 xxdec|xi1|mm1|gate 675:wwl0  c=1.81989e-17
c1887 xxdec|xi1|mm1|gate xxdec|xn1|mm0|gate  c=1.82431e-18
cg1886 xxdec|xi1|mm0|gate 0  c=4.15941e-16
c1885 xxdec|xi1|mm0|gate xxdec|xi1|mm0|drn  c=4.82168e-17
c1884 xxdec|xi1|mm0|gate 1233:xxdec|ab  c=2.83021e-18
c1883 xxdec|xi1|mm0|gate xxdec|xi1|mm1|drn  c=1.35765e-16
c1882 xxdec|xi1|mm0|gate 506:we  c=4.51717e-19
c1881 xxdec|xi1|mm0|gate 675:wwl0  c=1.31095e-16
c1880 xxdec|xi1|mm0|gate xxdec|xn1|mm0|gate  c=9.0485e-18
c1879 xxdec|xi1|mm0|gate 509:we  c=3.09519e-18
c1878 xxdec|xi1|mm0|gate 663:wwl0  c=1.26824e-18
c1877 xxdec|xi1|mm0|gate xxdec|xn0|mm1|gate  c=1.16642e-17
c1876 xxdec|xi1|mm0|gate xxdec|xn0|mm3|gate  c=1.80865e-18
cg1875 1233:xxdec|ab 0  c=4.23329e-16
c1874 1233:xxdec|ab 455:a  c=7.26193e-20
c1873 1233:xxdec|ab 453:a  c=1.083e-21
c1872 1233:xxdec|ab 503:we  c=3.65992e-19
c1871 1233:xxdec|ab 505:we  c=8.98967e-19
c1870 1233:xxdec|ab 506:we  c=9.73666e-17
c1869 1233:xxdec|ab 488:we  c=4.18276e-19
c1868 1233:xxdec|ab 495:we  c=1.02739e-18
c1867 1233:xxdec|ab 509:we  c=1.89053e-19
c1866 1233:xxdec|ab 510:we  c=1.40126e-17
c1865 1233:xxdec|ab 502:we  c=1.25591e-19
c1864 1233:xxdec|ab 482:re  c=9.85013e-17
c1863 1233:xxdec|ab 504:we  c=2.6184e-18
c1862 1233:xxdec|ab 507:we  c=5.64119e-21
c1861 1233:xxdec|ab 508:we  c=8.62633e-19
c1860 1233:xxdec|ab 457:a  c=5.08216e-19
c1859 1233:xxdec|ab xxdec|xn0|mm0|gate  c=3.63251e-18
c1858 1233:xxdec|ab 459:a  c=8.95368e-17
c1857 1233:xxdec|ab 438:a  c=5.08216e-19
c1856 1233:xxdec|ab 462:a  c=2.86392e-19
c1855 1233:xxdec|ab 460:a  c=3.6822e-20
c1854 1233:xxdec|ab 456:a  c=2.75576e-20
c1853 1233:xxdec|ab 454:a  c=4.31345e-20
cg1852 1232:xxdec|ab 0  c=4.07972e-16
c1851 1232:xxdec|ab 453:a  c=3.00863e-18
c1850 1232:xxdec|ab 505:we  c=6.02094e-19
c1849 1232:xxdec|ab 506:we  c=9.26008e-17
c1848 1232:xxdec|ab 495:we  c=6.88108e-19
c1847 1232:xxdec|ab 510:we  c=5.32927e-18
c1846 1232:xxdec|ab 482:re  c=9.46555e-17
c1845 1232:xxdec|ab 504:we  c=9.24753e-19
c1844 1232:xxdec|ab 508:we  c=3.0101e-19
c1843 1232:xxdec|ab xxdec|xn0|mm0|gate  c=1.35175e-17
c1842 1232:xxdec|ab 458:a  c=1.73097e-18
c1841 1232:xxdec|ab 459:a  c=7.94165e-17
c1840 1232:xxdec|ab xxdec|xi0|mm0|gate  c=1.22952e-16
c1839 1232:xxdec|ab xxdec|xi0|mm1|gate  c=1.52517e-17
c1838 1232:xxdec|ab 460:a  c=1.21515e-16
c1837 1232:xxdec|ab 442:a  c=2.66698e-18
c1836 1232:xxdec|ab 454:a  c=1.17819e-17
cg1835 1231:xxdec|ab 0  c=4.26525e-16
c1834 1231:xxdec|ab 450:a  c=6.66229e-20
c1833 1231:xxdec|ab 455:a  c=7.26193e-20
c1832 1231:xxdec|ab 479:re  c=6.87515e-19
c1831 1231:xxdec|ab 480:re  c=1.82839e-18
c1830 1231:xxdec|ab 482:re  c=1.0814e-16
c1829 1231:xxdec|ab 463:re  c=4.21752e-19
c1828 1231:xxdec|ab 471:re  c=1.02739e-18
c1827 1231:xxdec|ab 485:re  c=1.47132e-18
c1826 1231:xxdec|ab 452:a  c=7.62324e-19
c1825 1231:xxdec|ab 486:re  c=2.17693e-17
c1824 1231:xxdec|ab 457:a  c=5.08216e-19
c1823 1231:xxdec|ab 478:re  c=1.31953e-19
c1822 1231:xxdec|ab 481:re  c=2.6184e-18
c1821 1231:xxdec|ab 459:a  c=8.57067e-17
c1820 1231:xxdec|ab 483:re  c=5.52289e-21
c1819 1231:xxdec|ab 484:re  c=8.62633e-19
c1818 1231:xxdec|ab 428:a  c=8.60176e-19
c1817 1231:xxdec|ab 461:a  c=1.89395e-19
c1816 1231:xxdec|ab 462:a  c=1.89395e-19
c1815 1231:xxdec|ab 438:a  c=5.08216e-19
c1814 1231:xxdec|ab xxdec|xn2|mm0|gate  c=3.63251e-18
c1813 1231:xxdec|ab 451:a  c=2.55479e-20
c1812 1231:xxdec|ab 456:a  c=2.74477e-20
cg1811 1230:xxdec|ab 0  c=1.04817e-18
c1810 1230:xxdec|ab 459:a  c=1.53897e-17
c1809 1230:xxdec|ab 482:re  c=1.60186e-18
cg1808 1229:xxdec|ab 0  c=3.2221e-19
c1807 1229:xxdec|ab 459:a  c=1.88295e-17
c1806 1229:xxdec|ab 482:re  c=2.06431e-18
cg1805 1228:xxdec|ab 0  c=2.78484e-19
c1804 1228:xxdec|ab 459:a  c=1.88295e-17
c1803 1228:xxdec|ab 482:re  c=2.06431e-18
cg1802 1227:xxdec|ab 0  c=2.35205e-16
c1801 1227:xxdec|ab 455:a  c=1.03025e-17
c1800 1227:xxdec|ab 482:re  c=5.00771e-17
c1799 1227:xxdec|ab 471:re  c=2.83073e-18
c1798 1227:xxdec|ab 481:re  c=5.84283e-19
c1797 1227:xxdec|ab 459:a  c=3.92771e-16
c1796 1227:xxdec|ab 484:re  c=1.7252e-18
c1795 1227:xxdec|ab 438:a  c=2.38622e-17
c1794 1227:xxdec|ab 442:a  c=4.72133e-18
c1793 1227:xxdec|ab 456:a  c=1.7422e-18
cg1792 1226:xxdec|ab 0  c=5.51768e-19
c1791 1226:xxdec|ab 459:a  c=4.41764e-18
c1790 1226:xxdec|ab 482:re  c=2.92141e-19
cg1789 1225:xxdec|ab 0  c=1.21385e-17
c1788 1224:xxdec|ab 459:a  c=6.36812e-18
c1787 1224:xxdec|ab 482:re  c=5.84283e-19
cg1786 1223:xxdec|ab 0  c=1.13433e-17
c1785 1222:xxdec|ab 459:a  c=6.36812e-18
c1784 1222:xxdec|ab 482:re  c=2.92141e-19
cg1783 1221:xxdec|ab 0  c=1.1361e-17
cg1782 1208:xxdec|ab 0  c=1.16472e-17
cg1781 1204:xxdec|ab 0  c=1.05583e-17
cg1780 xxdec|xi0|mm1|drn 0  c=5.35623e-17
c1779 xxdec|xi0|mm1|drn 454:a  c=1.69637e-20
c1778 xxdec|xi0|mm1|drn xxdec|xn0|mm0|gate  c=3.43239e-18
c1777 xxdec|xi0|mm1|drn xxdec|xi0|mm0|gate  c=1.33257e-16
cg1776 xxdec|xi0|mm0|drn 0  c=2.00846e-17
c1775 xxdec|xi0|mm0|drn xxdec|xn0|mm0|gate  c=1.23631e-18
c1774 xxdec|xi0|mm0|drn xxdec|xi0|mm0|gate  c=4.82256e-17
cg1773 1202:xxdec|ab 0  c=1.04927e-17
cg1772 xxdec|xn0|mm3|gate 0  c=1.30974e-17
cg1771 xxdec|xn0|mm1|gate 0  c=2.20605e-16
c1770 xxdec|xn0|mm1|gate 506:we  c=7.92485e-21
c1769 xxdec|xn0|mm1|gate 510:we  c=3.62034e-18
c1768 xxdec|xn0|mm1|gate xxdec|xn0|mm0|gate  c=7.07635e-17
c1767 xxdec|xn0|mm1|gate xxdec|xn0|mm2|gate  c=1.14292e-17
cg1766 xxdec|xn2|mm3|gate 0  c=1.30974e-17
cg1765 xxdec|xn2|mm1|gate 0  c=2.15099e-16
c1764 xxdec|xn2|mm1|gate 486:re  c=3.62034e-18
c1763 xxdec|xn2|mm1|gate xxdec|xn2|mm0|gate  c=5.4752e-17
c1762 xxdec|xn2|mm1|gate xxdec|xn2|mm2|gate  c=1.14292e-17
cg1761 1197:xxarr|xi3|qb 0  c=3.1255e-17
c1760 1197:xxarr|xi3|qb 1135:ln_xarr|x_r1c1|n_63  c=1.31005e-17
c1759 1197:xxarr|xi3|qb 1158:xxarr|xi3|q  c=6.74098e-19
c1758 1197:xxarr|xi3|qb 313:ln_xarr|x_r1c1|n_64  c=1.14611e-20
c1757 1197:xxarr|xi3|qb 624:wwl1  c=1.01716e-16
c1756 1197:xxarr|xi3|qb 424:rwl1  c=8.19196e-17
c1755 1197:xxarr|xi3|qb 1161:xxarr|xi3|q  c=2.91224e-17
c1754 1197:xxarr|xi3|qb 1136:ln_xarr|x_r1c1|n_63  c=7.69046e-18
c1753 1197:xxarr|xi3|qb 310:ln_xarr|x_r1c1|n_62  c=3.18446e-17
c1752 1197:xxarr|xi3|qb 1141:xxarr|xi3|q  c=2.80033e-18
c1751 1197:xxarr|xi3|qb 761:wblb1  c=3.1388e-17
c1750 1197:xxarr|xi3|qb 308:ln_xarr|x_r1c1|n_62  c=1.89392e-17
c1749 1197:xxarr|xi3|qb 425:rwl1  c=3.17646e-23
c1748 1197:xxarr|xi3|qb 309:ln_xarr|x_r1c1|n_62  c=1.02803e-17
c1747 1197:xxarr|xi3|qb 1160:xxarr|xi3|q  c=8.01319e-18
c1746 1197:xxarr|xi3|qb 981:ln_xarr|x_r1c1|n_61  c=1.48536e-18
c1745 1197:xxarr|xi3|qb 1162:xxarr|xi3|q  c=1.29779e-18
c1744 1197:xxarr|xi3|qb 1159:xxarr|xi3|q  c=4.2217e-19
c1743 1197:xxarr|xi3|qb 314:ln_xarr|x_r1c1|n_64  c=1.01395e-18
cg1742 1196:xxarr|xi3|qb 0  c=1.06522e-17
c1741 1196:xxarr|xi3|qb 1159:xxarr|xi3|q  c=3.89245e-18
c1740 1196:xxarr|xi3|qb 308:ln_xarr|x_r1c1|n_62  c=1.52234e-18
c1739 1196:xxarr|xi3|qb 980:ln_xarr|x_r1c1|n_61  c=1.3721e-17
c1738 1196:xxarr|xi3|qb 979:ln_xarr|x_r1c1|n_61  c=6.70057e-18
cg1737 1195:xxarr|xi3|qb 0  c=7.62573e-17
c1736 1195:xxarr|xi3|qb 1135:ln_xarr|x_r1c1|n_63  c=9.32816e-20
c1735 1195:xxarr|xi3|qb 624:wwl1  c=3.5284e-18
c1734 1195:xxarr|xi3|qb 424:rwl1  c=1.0078e-16
c1733 1195:xxarr|xi3|qb 1161:xxarr|xi3|q  c=3.57297e-19
c1732 1195:xxarr|xi3|qb 761:wblb1  c=9.46715e-17
c1731 1195:xxarr|xi3|qb 425:rwl1  c=3.70442e-18
c1730 1195:xxarr|xi3|qb 1160:xxarr|xi3|q  c=3.61246e-18
c1729 1195:xxarr|xi3|qb 1159:xxarr|xi3|q  c=1.09512e-17
cg1728 1194:xxarr|xi3|qb 0  c=1.3106e-17
c1727 1194:xxarr|xi3|qb 761:wblb1  c=1.03908e-18
c1726 1194:xxarr|xi3|qb 313:ln_xarr|x_r1c1|n_64  c=1.88657e-17
cg1725 1193:xxarr|xi3|qb 0  c=7.47279e-18
c1724 1193:xxarr|xi3|qb 624:wwl1  c=1.48305e-18
c1723 1193:xxarr|xi3|qb 313:ln_xarr|x_r1c1|n_64  c=4.74906e-17
c1722 1193:xxarr|xi3|qb 424:rwl1  c=2.52195e-17
c1721 1193:xxarr|xi3|qb 761:wblb1  c=4.4968e-18
c1720 1193:xxarr|xi3|qb 425:rwl1  c=8.00301e-18
c1719 1193:xxarr|xi3|qb 314:ln_xarr|x_r1c1|n_64  c=7.28183e-18
cg1718 1192:xxarr|xi3|qb 0  c=7.56897e-17
c1717 1192:xxarr|xi3|qb 313:ln_xarr|x_r1c1|n_64  c=1.14611e-20
c1716 1192:xxarr|xi3|qb 1144:xxarr|xi3|q  c=2.16098e-18
c1715 1192:xxarr|xi3|qb 761:wblb1  c=1.33428e-17
c1714 1192:xxarr|xi3|qb 308:ln_xarr|x_r1c1|n_62  c=2.18148e-17
c1713 1192:xxarr|xi3|qb 979:ln_xarr|x_r1c1|n_61  c=6.65085e-20
c1712 1192:xxarr|xi3|qb 1159:xxarr|xi3|q  c=6.57226e-19
cg1711 1191:xxarr|xi3|qb 0  c=4.7706e-18
c1710 1191:xxarr|xi3|qb 424:rwl1  c=2.35425e-17
c1709 1191:xxarr|xi3|qb 1161:xxarr|xi3|q  c=2.21013e-18
c1708 1191:xxarr|xi3|qb 1136:ln_xarr|x_r1c1|n_63  c=7.61222e-20
c1707 1191:xxarr|xi3|qb 1144:xxarr|xi3|q  c=1.35095e-19
c1706 1191:xxarr|xi3|qb 761:wblb1  c=9.95195e-21
c1705 1191:xxarr|xi3|qb 308:ln_xarr|x_r1c1|n_62  c=1.00134e-17
c1704 1191:xxarr|xi3|qb 309:ln_xarr|x_r1c1|n_62  c=3.97247e-19
c1703 1191:xxarr|xi3|qb 1160:xxarr|xi3|q  c=1.29456e-18
c1702 1191:xxarr|xi3|qb 981:ln_xarr|x_r1c1|n_61  c=6.2621e-18
c1701 1191:xxarr|xi3|qb 980:ln_xarr|x_r1c1|n_61  c=4.91137e-17
c1700 1191:xxarr|xi3|qb 1159:xxarr|xi3|q  c=2.01139e-17
c1699 1189:xxarr|xi3|qb 624:wwl1  c=1.22759e-19
c1698 1189:xxarr|xi3|qb 313:ln_xarr|x_r1c1|n_64  c=2.37089e-19
c1697 1189:xxarr|xi3|qb 424:rwl1  c=7.85861e-18
c1696 1189:xxarr|xi3|qb 1161:xxarr|xi3|q  c=1.79816e-19
c1695 1189:xxarr|xi3|qb 1144:xxarr|xi3|q  c=1.04867e-18
c1694 1189:xxarr|xi3|qb 761:wblb1  c=7.6132e-18
c1693 1189:xxarr|xi3|qb 308:ln_xarr|x_r1c1|n_62  c=1.93171e-17
c1692 1189:xxarr|xi3|qb 1160:xxarr|xi3|q  c=4.58554e-19
c1691 1189:xxarr|xi3|qb 981:ln_xarr|x_r1c1|n_61  c=1.45079e-19
c1690 1189:xxarr|xi3|qb 980:ln_xarr|x_r1c1|n_61  c=4.28158e-19
c1689 1189:xxarr|xi3|qb 979:ln_xarr|x_r1c1|n_61  c=1.45078e-19
c1688 1189:xxarr|xi3|qb 1159:xxarr|xi3|q  c=4.34902e-20
cg1687 1171:xxarr|xi3|qb 0  c=5.36383e-18
c1686 1171:xxarr|xi3|qb 981:ln_xarr|x_r1c1|n_61  c=1.77314e-19
c1685 1171:xxarr|xi3|qb 980:ln_xarr|x_r1c1|n_61  c=2.58857e-18
c1684 1171:xxarr|xi3|qb 1159:xxarr|xi3|q  c=2.85102e-18
c1683 1171:xxarr|xi3|qb 308:ln_xarr|x_r1c1|n_62  c=2.04324e-18
cg1682 xxarr|xi3|mpu2|drn 0  c=3.80607e-17
c1681 xxarr|xi3|mpu2|drn 1136:ln_xarr|x_r1c1|n_63  c=1.26969e-18
c1680 xxarr|xi3|mpu2|drn 308:ln_xarr|x_r1c1|n_62  c=2.08182e-17
c1679 xxarr|xi3|mpu2|drn 1138:xxarr|xi3|q  c=1.77411e-19
cg1678 xxarr|xi3|mpd2|drn 0  c=3.11423e-17
c1677 xxarr|xi3|mpd2|drn 310:ln_xarr|x_r1c1|n_62  c=1.04718e-17
c1676 xxarr|xi3|mpd2|drn 1136:ln_xarr|x_r1c1|n_63  c=1.22618e-17
c1675 xxarr|xi3|mpd2|drn 1135:ln_xarr|x_r1c1|n_63  c=4.36084e-18
c1674 xxarr|xi3|mpd2|drn xxarr|xi3|mpg2|src  c=2.86429e-17
c1673 xxarr|xi3|mpd2|drn xxarr|xi3|mpg1|src  c=1.77411e-19
cg1672 1168:xxarr|xi3|qb 0  c=3.34107e-18
c1671 1168:xxarr|xi3|qb 310:ln_xarr|x_r1c1|n_62  c=2.05045e-18
c1670 1168:xxarr|xi3|qb 1136:ln_xarr|x_r1c1|n_63  c=2.93644e-18
c1669 1168:xxarr|xi3|qb 1135:ln_xarr|x_r1c1|n_63  c=1.42833e-22
cg1668 1166:xxarr|xi3|qb 0  c=3.80966e-18
cg1667 1162:xxarr|xi3|q 0  c=3.35954e-17
c1666 1162:xxarr|xi3|q 788:wbl1  c=1.66138e-17
c1665 1162:xxarr|xi3|q 624:wwl1  c=8.53263e-17
c1664 1162:xxarr|xi3|q 1136:ln_xarr|x_r1c1|n_63  c=8.56291e-18
c1663 1162:xxarr|xi3|q 310:ln_xarr|x_r1c1|n_62  c=8.56737e-19
c1662 1162:xxarr|xi3|q 625:wwl1  c=1.78728e-18
c1661 1162:xxarr|xi3|q 586:wwl1  c=2.43908e-18
c1660 1162:xxarr|xi3|q 620:wwl1  c=2.94004e-19
c1659 1162:xxarr|xi3|q 981:ln_xarr|x_r1c1|n_61  c=2.76196e-17
c1658 1162:xxarr|xi3|q 1133:ln_xarr|x_r1c1|n_63  c=1.65532e-17
cg1657 1161:xxarr|xi3|q 0  c=4.57528e-18
c1656 1161:xxarr|xi3|q 788:wbl1  c=6.29365e-20
c1655 1161:xxarr|xi3|q 624:wwl1  c=1.23168e-17
c1654 1161:xxarr|xi3|q 424:rwl1  c=1.27549e-17
c1653 1161:xxarr|xi3|q 1136:ln_xarr|x_r1c1|n_63  c=1.81732e-19
c1652 1161:xxarr|xi3|q 310:ln_xarr|x_r1c1|n_62  c=1.43046e-17
c1651 1161:xxarr|xi3|q 308:ln_xarr|x_r1c1|n_62  c=1.352e-17
c1650 1161:xxarr|xi3|q 309:ln_xarr|x_r1c1|n_62  c=3.98465e-17
c1649 1161:xxarr|xi3|q 981:ln_xarr|x_r1c1|n_61  c=1.00959e-17
cg1648 1160:xxarr|xi3|q 0  c=2.00156e-17
c1647 1160:xxarr|xi3|q 788:wbl1  c=6.50506e-18
c1646 1160:xxarr|xi3|q 624:wwl1  c=5.35324e-17
c1645 1160:xxarr|xi3|q 424:rwl1  c=5.28618e-17
cg1644 1159:xxarr|xi3|q 0  c=7.92558e-17
c1643 1159:xxarr|xi3|q 788:wbl1  c=3.17025e-17
c1642 1159:xxarr|xi3|q 424:rwl1  c=7.81394e-17
c1641 1159:xxarr|xi3|q 308:ln_xarr|x_r1c1|n_62  c=8.12398e-19
c1640 1159:xxarr|xi3|q 981:ln_xarr|x_r1c1|n_61  c=1.94492e-17
c1639 1159:xxarr|xi3|q 980:ln_xarr|x_r1c1|n_61  c=1.03653e-17
c1638 1159:xxarr|xi3|q 392:rwl1  c=3.90595e-18
c1637 1159:xxarr|xi3|q 979:ln_xarr|x_r1c1|n_61  c=2.36097e-17
c1636 1158:xxarr|xi3|q 788:wbl1  c=9.28488e-18
c1635 1158:xxarr|xi3|q 624:wwl1  c=7.95323e-18
c1634 1158:xxarr|xi3|q 424:rwl1  c=7.72508e-18
c1633 1158:xxarr|xi3|q 1136:ln_xarr|x_r1c1|n_63  c=6.13076e-20
c1632 1158:xxarr|xi3|q 310:ln_xarr|x_r1c1|n_62  c=1.73008e-19
c1631 1158:xxarr|xi3|q 308:ln_xarr|x_r1c1|n_62  c=1.73008e-19
c1630 1158:xxarr|xi3|q 620:wwl1  c=1.72316e-19
c1629 1158:xxarr|xi3|q 309:ln_xarr|x_r1c1|n_62  c=7.08748e-19
c1628 1158:xxarr|xi3|q 981:ln_xarr|x_r1c1|n_61  c=1.69637e-17
c1627 1158:xxarr|xi3|q 591:wwl1  c=1.60373e-20
c1626 1158:xxarr|xi3|q 392:rwl1  c=1.60373e-20
cg1625 1144:xxarr|xi3|q 0  c=5.4401e-18
c1624 1144:xxarr|xi3|q 310:ln_xarr|x_r1c1|n_62  c=2.13866e-20
c1623 1144:xxarr|xi3|q 309:ln_xarr|x_r1c1|n_62  c=3.69271e-19
c1622 1144:xxarr|xi3|q 979:ln_xarr|x_r1c1|n_61  c=2.04324e-18
cg1621 xxarr|xi3|mpg1|src 0  c=3.13189e-17
c1620 xxarr|xi3|mpg1|src 981:ln_xarr|x_r1c1|n_61  c=4.35818e-18
c1619 xxarr|xi3|mpg1|src 1136:ln_xarr|x_r1c1|n_63  c=1.23487e-17
c1618 xxarr|xi3|mpg1|src 763:wbl1  c=2.8718e-17
c1617 xxarr|xi3|mpg1|src 1133:ln_xarr|x_r1c1|n_63  c=1.04744e-17
cg1616 1141:xxarr|xi3|q 0  c=1.11456e-18
c1615 1141:xxarr|xi3|q 1136:ln_xarr|x_r1c1|n_63  c=2.91117e-18
c1614 1141:xxarr|xi3|q 1135:ln_xarr|x_r1c1|n_63  c=2.05046e-18
cg1613 1138:xxarr|xi3|q 0  c=3.5543e-17
c1612 1138:xxarr|xi3|q 1136:ln_xarr|x_r1c1|n_63  c=1.26969e-18
c1611 1138:xxarr|xi3|q 979:ln_xarr|x_r1c1|n_61  c=2.08119e-17
cg1610 1137:ln_xarr|x_r1c1|n_63 0  c=1.06916e-17
c1609 1137:ln_xarr|x_r1c1|n_63 788:wbl1  c=5.6761e-20
c1608 1137:ln_xarr|x_r1c1|n_63 625:wwl1  c=3.4448e-17
c1607 1137:ln_xarr|x_r1c1|n_63 620:wwl1  c=1.95231e-18
cg1606 1136:ln_xarr|x_r1c1|n_63 0  c=1.04343e-16
c1605 1136:ln_xarr|x_r1c1|n_63 788:wbl1  c=7.25668e-18
c1604 1136:ln_xarr|x_r1c1|n_63 615:wwl1  c=2.73661e-18
c1603 1136:ln_xarr|x_r1c1|n_63 310:ln_xarr|x_r1c1|n_62  c=1.11938e-17
c1602 1136:ln_xarr|x_r1c1|n_63 763:wbl1  c=1.08947e-17
c1601 1136:ln_xarr|x_r1c1|n_63 625:wwl1  c=1.6046e-17
c1600 1136:ln_xarr|x_r1c1|n_63 586:wwl1  c=2.69977e-18
c1599 1136:ln_xarr|x_r1c1|n_63 765:wbl1  c=8.33292e-19
c1598 1136:ln_xarr|x_r1c1|n_63 309:ln_xarr|x_r1c1|n_62  c=1.18936e-19
c1597 1136:ln_xarr|x_r1c1|n_63 981:ln_xarr|x_r1c1|n_61  c=1.11273e-17
c1596 1136:ln_xarr|x_r1c1|n_63 980:ln_xarr|x_r1c1|n_61  c=3.81442e-19
cg1595 1135:ln_xarr|x_r1c1|n_63 0  c=1.45325e-17
c1594 1135:ln_xarr|x_r1c1|n_63 624:wwl1  c=6.22962e-19
c1593 1135:ln_xarr|x_r1c1|n_63 xxarr|xi3|mpg2|src  c=2.08714e-17
c1592 1135:ln_xarr|x_r1c1|n_63 310:ln_xarr|x_r1c1|n_62  c=1.22014e-17
c1591 1135:ln_xarr|x_r1c1|n_63 761:wblb1  c=2.16006e-17
c1590 1135:ln_xarr|x_r1c1|n_63 981:ln_xarr|x_r1c1|n_61  c=4.72549e-19
cg1589 1133:ln_xarr|x_r1c1|n_63 0  c=6.47105e-18
c1588 1133:ln_xarr|x_r1c1|n_63 788:wbl1  c=1.8217e-17
c1587 1133:ln_xarr|x_r1c1|n_63 624:wwl1  c=6.22962e-19
c1586 1133:ln_xarr|x_r1c1|n_63 310:ln_xarr|x_r1c1|n_62  c=3.54163e-19
c1585 1133:ln_xarr|x_r1c1|n_63 763:wbl1  c=1.42782e-17
c1584 1133:ln_xarr|x_r1c1|n_63 625:wwl1  c=6.20574e-18
c1583 1133:ln_xarr|x_r1c1|n_63 620:wwl1  c=2.14164e-19
c1582 1133:ln_xarr|x_r1c1|n_63 981:ln_xarr|x_r1c1|n_61  c=1.22427e-17
cg1581 1132:ln_xarr|x_r0c1|n_65 0  c=4.49033e-18
c1580 1132:ln_xarr|x_r0c1|n_65 312:ln_xarr|x_r0c1|n_64  c=2.77122e-18
c1579 1132:ln_xarr|x_r0c1|n_65 716:rbl1  c=1.72138e-18
c1578 1132:ln_xarr|x_r0c1|n_65 911:rwl0  c=1.13381e-17
cg1577 1131:ln_xarr|x_r0c1|n_65 0  c=7.21906e-18
c1576 1131:ln_xarr|x_r0c1|n_65 312:ln_xarr|x_r0c1|n_64  c=1.21674e-17
c1575 1131:ln_xarr|x_r0c1|n_65 xxarr|xi1|mra2|drn  c=2.07401e-17
c1574 1131:ln_xarr|x_r0c1|n_65 716:rbl1  c=2.15885e-17
c1573 1131:ln_xarr|x_r0c1|n_65 xxarr|xi1|mra1|drn  c=4.35855e-18
c1572 1131:ln_xarr|x_r0c1|n_65 978:xxarr|xi1|net5  c=1.54511e-17
cg1571 1130:ln_xarr|x_r0c1|n_65 0  c=1.21146e-17
c1570 1130:ln_xarr|x_r0c1|n_65 312:ln_xarr|x_r0c1|n_64  c=4.09833e-17
c1569 1130:ln_xarr|x_r0c1|n_65 874:rwl0  c=3.87717e-18
c1568 1130:ln_xarr|x_r0c1|n_65 716:rbl1  c=4.36605e-17
c1567 1130:ln_xarr|x_r0c1|n_65 xxarr|xi1|mra1|drn  c=1.61315e-18
c1566 1130:ln_xarr|x_r0c1|n_65 911:rwl0  c=4.62273e-17
c1565 1130:ln_xarr|x_r0c1|n_65 978:xxarr|xi1|net5  c=1.11545e-18
cg1564 1129:ln_xarr|x_r1c1|n_65 0  c=8.61487e-18
c1563 1129:ln_xarr|x_r1c1|n_65 716:rbl1  c=2.49956e-17
c1562 1129:ln_xarr|x_r1c1|n_65 701:rbl1  c=3.7759e-19
c1561 1129:ln_xarr|x_r1c1|n_65 xxarr|xi3|mra2|drn  c=2.07401e-17
c1560 1129:ln_xarr|x_r1c1|n_65 1120:xxarr|xi3|net5  c=1.52174e-17
c1559 1129:ln_xarr|x_r1c1|n_65 xxarr|xi3|mra1|drn  c=4.35855e-18
c1558 1129:ln_xarr|x_r1c1|n_65 715:rbl1  c=1.02288e-19
c1557 1129:ln_xarr|x_r1c1|n_65 314:ln_xarr|x_r1c1|n_64  c=1.20404e-17
cg1556 1128:ln_xarr|x_r1c1|n_65 0  c=4.49509e-18
c1555 1128:ln_xarr|x_r1c1|n_65 425:rwl1  c=1.13381e-17
c1554 1128:ln_xarr|x_r1c1|n_65 314:ln_xarr|x_r1c1|n_64  c=2.77122e-18
c1553 1128:ln_xarr|x_r1c1|n_65 716:rbl1  c=1.72138e-18
c1552 1128:ln_xarr|x_r1c1|n_65 714:rbl1  c=3.9909e-22
cg1551 1127:ln_xarr|x_r1c1|n_65 0  c=7.89707e-18
c1550 1127:ln_xarr|x_r1c1|n_65 425:rwl1  c=1.44269e-17
c1549 1127:ln_xarr|x_r1c1|n_65 314:ln_xarr|x_r1c1|n_64  c=2.70216e-17
c1548 1127:ln_xarr|x_r1c1|n_65 716:rbl1  c=3.52677e-17
cg1547 1126:ln_xarr|x_r1c1|n_65 0  c=4.17871e-18
c1546 1126:ln_xarr|x_r1c1|n_65 714:rbl1  c=6.64799e-19
c1545 1126:ln_xarr|x_r1c1|n_65 716:rbl1  c=8.39281e-18
c1544 1126:ln_xarr|x_r1c1|n_65 xxrs1|xis1|mm0|gate  c=4.43323e-22
c1543 1126:ln_xarr|x_r1c1|n_65 425:rwl1  c=3.17931e-17
c1542 1126:ln_xarr|x_r1c1|n_65 1120:xxarr|xi3|net5  c=1.10932e-18
c1541 1126:ln_xarr|x_r1c1|n_65 xxarr|xi3|mra1|drn  c=1.64074e-18
c1540 1126:ln_xarr|x_r1c1|n_65 715:rbl1  c=1.7739e-19
c1539 1126:ln_xarr|x_r1c1|n_65 314:ln_xarr|x_r1c1|n_64  c=1.39617e-17
cg1538 1125:ln_xarr|x_r0c1|n_63 0  c=7.57257e-18
c1537 1125:ln_xarr|x_r0c1|n_63 677:wwl0  c=3.30089e-17
c1536 1125:ln_xarr|x_r0c1|n_63 788:wbl1  c=4.25942e-18
c1535 1125:ln_xarr|x_r0c1|n_63 673:wwl0  c=1.95231e-18
c1534 1125:ln_xarr|x_r0c1|n_63 783:wbl1  c=8.27461e-19
cg1533 1124:ln_xarr|x_r0c1|n_63 0  c=8.31633e-17
c1532 1124:ln_xarr|x_r0c1|n_63 xxarr|xi1|mpd2|drn  c=1.23422e-17
c1531 1124:ln_xarr|x_r0c1|n_63 913:ln_xarr|x_r0c1|n_61  c=1.13655e-17
c1530 1124:ln_xarr|x_r0c1|n_63 1002:xxarr|xi1|q  c=1.76544e-20
c1529 1124:ln_xarr|x_r0c1|n_63 1035:xxarr|xi1|qb  c=7.56926e-18
c1528 1124:ln_xarr|x_r0c1|n_63 762:wblb1  c=1.8053e-19
c1527 1124:ln_xarr|x_r0c1|n_63 788:wbl1  c=2.89728e-17
c1526 1124:ln_xarr|x_r0c1|n_63 783:wbl1  c=4.9626e-18
c1525 1124:ln_xarr|x_r0c1|n_63 982:xxarr|xi1|q  c=1.26969e-18
c1524 1124:ln_xarr|x_r0c1|n_63 751:wblb1  c=2.60254e-18
c1523 1124:ln_xarr|x_r0c1|n_63 1005:xxarr|xi1|q  c=1.81732e-19
c1522 1124:ln_xarr|x_r0c1|n_63 xxarr|xi1|mpu2|drn  c=1.26969e-18
c1521 1124:ln_xarr|x_r0c1|n_63 999:xxarr|xi1|q  c=2.91996e-18
c1520 1124:ln_xarr|x_r0c1|n_63 761:wblb1  c=7.58439e-18
c1519 1124:ln_xarr|x_r0c1|n_63 763:wbl1  c=8.33292e-19
c1518 1124:ln_xarr|x_r0c1|n_63 1030:xxarr|xi1|qb  c=2.68111e-18
c1517 1124:ln_xarr|x_r0c1|n_63 677:wwl0  c=1.28895e-17
c1516 1124:ln_xarr|x_r0c1|n_63 318:ln_xarr|x_r0c1|n_62  c=5.35821e-18
c1515 1124:ln_xarr|x_r0c1|n_63 1041:xxarr|xi1|qb  c=7.61222e-20
c1514 1124:ln_xarr|x_r0c1|n_63 765:wbl1  c=1.13631e-17
c1513 1124:ln_xarr|x_r0c1|n_63 755:wblb1  c=1.68182e-18
c1512 1124:ln_xarr|x_r0c1|n_63 319:ln_xarr|x_r0c1|n_62  c=1.18936e-19
c1511 1124:ln_xarr|x_r0c1|n_63 xxwd1|xi1|mm0|drn  c=6.41179e-19
c1510 1124:ln_xarr|x_r0c1|n_63 785:wbl1  c=5.18639e-18
c1509 1124:ln_xarr|x_r0c1|n_63 xxwd1|xi1|mm1|gate  c=2.01946e-18
c1508 1124:ln_xarr|x_r0c1|n_63 xxwd1|xi1|mm1|drn  c=1.89954e-18
c1507 1124:ln_xarr|x_r0c1|n_63 xxarr|xi1|mpg1|src  c=1.27288e-17
c1506 1124:ln_xarr|x_r0c1|n_63 759:wblb1  c=1.27415e-19
c1505 1124:ln_xarr|x_r0c1|n_63 1003:xxarr|xi1|q  c=8.21779e-18
c1504 1124:ln_xarr|x_r0c1|n_63 915:ln_xarr|x_r0c1|n_61  c=3.81442e-19
cg1503 1123:ln_xarr|x_r0c1|n_63 0  c=1.11299e-17
c1502 1123:ln_xarr|x_r0c1|n_63 xxarr|xi1|mpd2|drn  c=4.36084e-18
c1501 1123:ln_xarr|x_r0c1|n_63 913:ln_xarr|x_r0c1|n_61  c=3.54163e-19
c1500 1123:ln_xarr|x_r0c1|n_63 1035:xxarr|xi1|qb  c=1.3751e-17
c1499 1123:ln_xarr|x_r0c1|n_63 1038:xxarr|xi1|qb  c=3.47766e-19
c1498 1123:ln_xarr|x_r0c1|n_63 676:wwl0  c=6.65274e-19
c1497 1123:ln_xarr|x_r0c1|n_63 xxarr|xi3|mpg2|src  c=5.87933e-21
c1496 1123:ln_xarr|x_r0c1|n_63 999:xxarr|xi1|q  c=2.05046e-18
c1495 1123:ln_xarr|x_r0c1|n_63 761:wblb1  c=3.18002e-17
c1494 1123:ln_xarr|x_r0c1|n_63 1030:xxarr|xi1|qb  c=1.42833e-22
c1493 1123:ln_xarr|x_r0c1|n_63 318:ln_xarr|x_r0c1|n_62  c=1.21109e-17
c1492 1123:ln_xarr|x_r0c1|n_63 1036:xxarr|xi1|qb  c=9.32816e-20
c1491 1123:ln_xarr|x_r0c1|n_63 xxarr|xi1|mpg2|src  c=2.08714e-17
cg1490 1121:ln_xarr|x_r0c1|n_63 0  c=6.67085e-18
c1489 1121:ln_xarr|x_r0c1|n_63 913:ln_xarr|x_r0c1|n_61  c=1.42346e-17
c1488 1121:ln_xarr|x_r0c1|n_63 1002:xxarr|xi1|q  c=1.00699e-18
c1487 1121:ln_xarr|x_r0c1|n_63 788:wbl1  c=2.77054e-17
c1486 1121:ln_xarr|x_r0c1|n_63 751:wblb1  c=2.9342e-20
c1485 1121:ln_xarr|x_r0c1|n_63 676:wwl0  c=6.65274e-19
c1484 1121:ln_xarr|x_r0c1|n_63 999:xxarr|xi1|q  c=1.42833e-22
c1483 1121:ln_xarr|x_r0c1|n_63 763:wbl1  c=5.87933e-21
c1482 1121:ln_xarr|x_r0c1|n_63 1030:xxarr|xi1|qb  c=2.05046e-18
c1481 1121:ln_xarr|x_r0c1|n_63 677:wwl0  c=3.48815e-18
c1480 1121:ln_xarr|x_r0c1|n_63 318:ln_xarr|x_r0c1|n_62  c=3.54163e-19
c1479 1121:ln_xarr|x_r0c1|n_63 765:wbl1  c=1.42782e-17
c1478 1121:ln_xarr|x_r0c1|n_63 673:wwl0  c=2.14164e-19
c1477 1121:ln_xarr|x_r0c1|n_63 xxwd1|xi1|mm1|gate  c=2.4017e-20
c1476 1121:ln_xarr|x_r0c1|n_63 xxarr|xi1|mpg1|src  c=1.04744e-17
c1475 1121:ln_xarr|x_r0c1|n_63 1003:xxarr|xi1|q  c=1.70394e-17
cg1474 1120:xxarr|xi3|net5 0  c=4.51367e-17
c1473 1120:xxarr|xi3|net5 714:rbl1  c=5.41959e-19
c1472 1120:xxarr|xi3|net5 624:wwl1  c=3.38446e-17
c1471 1120:xxarr|xi3|net5 313:ln_xarr|x_r1c1|n_64  c=2.99821e-19
c1470 1120:xxarr|xi3|net5 716:rbl1  c=1.46069e-17
c1469 1120:xxarr|xi3|net5 717:rbl1  c=1.29176e-19
c1468 1120:xxarr|xi3|net5 715:rbl1  c=3.32754e-18
c1467 1120:xxarr|xi3|net5 708:rbl1  c=7.44608e-19
c1466 1120:xxarr|xi3|net5 314:ln_xarr|x_r1c1|n_64  c=1.63523e-17
cg1465 xxarr|xi3|mra1|drn 0  c=2.9697e-17
c1464 xxarr|xi3|mra1|drn 314:ln_xarr|x_r1c1|n_64  c=1.04514e-17
c1463 xxarr|xi3|mra1|drn 313:ln_xarr|x_r1c1|n_64  c=3.72463e-19
c1462 xxarr|xi3|mra1|drn 714:rbl1  c=2.16565e-18
c1461 xxarr|xi3|mra1|drn xxarr|xi3|mra2|drn  c=2.8718e-17
cg1460 1117:xxarr|xi2|qb 0  c=3.59059e-17
c1459 1117:xxarr|xi2|qb 306:ln_xarr|x_r1c0|n_64  c=1.14611e-20
c1458 1117:xxarr|xi2|qb 1081:xxarr|xi2|q  c=1.29857e-18
c1457 1117:xxarr|xi2|qb 1079:xxarr|xi2|q  c=4.22849e-19
c1456 1117:xxarr|xi2|qb 1078:xxarr|xi2|q  c=6.74098e-19
c1455 1117:xxarr|xi2|qb 1056:ln_xarr|x_r1c0|n_63  c=7.63226e-18
c1454 1117:xxarr|xi2|qb 1055:ln_xarr|x_r1c0|n_63  c=1.31005e-17
c1453 1117:xxarr|xi2|qb 301:ln_xarr|x_r1c0|n_62  c=3.18448e-17
c1452 1117:xxarr|xi2|qb 1061:xxarr|xi2|q  c=2.80033e-18
c1451 1117:xxarr|xi2|qb 1080:xxarr|xi2|q  c=7.91686e-18
c1450 1117:xxarr|xi2|qb 299:ln_xarr|x_r1c0|n_62  c=1.89393e-17
c1449 1117:xxarr|xi2|qb 1082:xxarr|xi2|q  c=2.91224e-17
c1448 1117:xxarr|xi2|qb 300:ln_xarr|x_r1c0|n_62  c=1.02803e-17
c1447 1117:xxarr|xi2|qb 343:ln_xarr|x_r1c0|n_61  c=1.48536e-18
c1446 1117:xxarr|xi2|qb 591:wwl1  c=1.01713e-16
c1445 1117:xxarr|xi2|qb 392:rwl1  c=8.19171e-17
c1444 1117:xxarr|xi2|qb 832:wblb0  c=3.1388e-17
c1443 1117:xxarr|xi2|qb 427:rwl1  c=3.17646e-23
c1442 1117:xxarr|xi2|qb 307:ln_xarr|x_r1c0|n_64  c=1.01395e-18
cg1441 1116:xxarr|xi2|qb 0  c=1.31571e-17
c1440 1116:xxarr|xi2|qb 832:wblb0  c=1.03908e-18
c1439 1116:xxarr|xi2|qb 306:ln_xarr|x_r1c0|n_64  c=1.88649e-17
cg1438 1115:xxarr|xi2|qb 0  c=7.57929e-17
c1437 1115:xxarr|xi2|qb 1079:xxarr|xi2|q  c=1.1042e-17
c1436 1115:xxarr|xi2|qb 1055:ln_xarr|x_r1c0|n_63  c=9.32816e-20
c1435 1115:xxarr|xi2|qb 1080:xxarr|xi2|q  c=3.61246e-18
c1434 1115:xxarr|xi2|qb 420:rwl1  c=5.27921e-19
c1433 1115:xxarr|xi2|qb 1082:xxarr|xi2|q  c=3.57297e-19
c1432 1115:xxarr|xi2|qb 591:wwl1  c=3.5284e-18
c1431 1115:xxarr|xi2|qb 392:rwl1  c=1.0078e-16
c1430 1115:xxarr|xi2|qb 832:wblb0  c=9.46715e-17
c1429 1115:xxarr|xi2|qb 427:rwl1  c=3.71364e-18
c1428 1115:xxarr|xi2|qb 593:wwl1  c=1.95477e-18
cg1427 1114:xxarr|xi2|qb 0  c=1.06522e-17
c1426 1114:xxarr|xi2|qb 1079:xxarr|xi2|q  c=3.89245e-18
c1425 1114:xxarr|xi2|qb 299:ln_xarr|x_r1c0|n_62  c=1.52234e-18
c1424 1114:xxarr|xi2|qb 342:ln_xarr|x_r1c0|n_61  c=1.3721e-17
c1423 1114:xxarr|xi2|qb 341:ln_xarr|x_r1c0|n_61  c=6.70057e-18
cg1422 1113:xxarr|xi2|qb 0  c=4.7706e-18
c1421 1113:xxarr|xi2|qb 1079:xxarr|xi2|q  c=2.01139e-17
c1420 1113:xxarr|xi2|qb 1056:ln_xarr|x_r1c0|n_63  c=7.61222e-20
c1419 1113:xxarr|xi2|qb 1080:xxarr|xi2|q  c=1.29456e-18
c1418 1113:xxarr|xi2|qb 299:ln_xarr|x_r1c0|n_62  c=1.00134e-17
c1417 1113:xxarr|xi2|qb 1082:xxarr|xi2|q  c=2.21013e-18
c1416 1113:xxarr|xi2|qb 300:ln_xarr|x_r1c0|n_62  c=3.97247e-19
c1415 1113:xxarr|xi2|qb 343:ln_xarr|x_r1c0|n_61  c=6.2621e-18
c1414 1113:xxarr|xi2|qb 342:ln_xarr|x_r1c0|n_61  c=4.91137e-17
c1413 1113:xxarr|xi2|qb 1064:xxarr|xi2|q  c=1.35095e-19
c1412 1113:xxarr|xi2|qb 392:rwl1  c=2.35232e-17
c1411 1113:xxarr|xi2|qb 832:wblb0  c=9.95195e-21
c1410 1111:xxarr|xi2|qb 306:ln_xarr|x_r1c0|n_64  c=2.37089e-19
c1409 1111:xxarr|xi2|qb 1079:xxarr|xi2|q  c=4.34902e-20
c1408 1111:xxarr|xi2|qb 1080:xxarr|xi2|q  c=4.58554e-19
c1407 1111:xxarr|xi2|qb 299:ln_xarr|x_r1c0|n_62  c=1.9305e-17
c1406 1111:xxarr|xi2|qb 1082:xxarr|xi2|q  c=1.79816e-19
c1405 1111:xxarr|xi2|qb 343:ln_xarr|x_r1c0|n_61  c=1.45078e-19
c1404 1111:xxarr|xi2|qb 342:ln_xarr|x_r1c0|n_61  c=4.28158e-19
c1403 1111:xxarr|xi2|qb 591:wwl1  c=1.22759e-19
c1402 1111:xxarr|xi2|qb 341:ln_xarr|x_r1c0|n_61  c=1.45078e-19
c1401 1111:xxarr|xi2|qb 1064:xxarr|xi2|q  c=1.04867e-18
c1400 1111:xxarr|xi2|qb 392:rwl1  c=7.85861e-18
c1399 1111:xxarr|xi2|qb 832:wblb0  c=7.6132e-18
cg1398 1110:xxarr|xi2|qb 0  c=7.56897e-17
c1397 1110:xxarr|xi2|qb 306:ln_xarr|x_r1c0|n_64  c=1.14611e-20
c1396 1110:xxarr|xi2|qb 1079:xxarr|xi2|q  c=6.57226e-19
c1395 1110:xxarr|xi2|qb 299:ln_xarr|x_r1c0|n_62  c=2.18003e-17
c1394 1110:xxarr|xi2|qb 341:ln_xarr|x_r1c0|n_61  c=6.65085e-20
c1393 1110:xxarr|xi2|qb 1064:xxarr|xi2|q  c=2.16575e-18
c1392 1110:xxarr|xi2|qb 832:wblb0  c=1.33428e-17
cg1391 1109:xxarr|xi2|qb 0  c=8.18871e-18
c1390 1109:xxarr|xi2|qb 306:ln_xarr|x_r1c0|n_64  c=4.74781e-17
c1389 1109:xxarr|xi2|qb 591:wwl1  c=1.48305e-18
c1388 1109:xxarr|xi2|qb 392:rwl1  c=2.51993e-17
c1387 1109:xxarr|xi2|qb 832:wblb0  c=4.4968e-18
c1386 1109:xxarr|xi2|qb 427:rwl1  c=8.00301e-18
c1385 1109:xxarr|xi2|qb 307:ln_xarr|x_r1c0|n_64  c=7.2778e-18
cg1384 1091:xxarr|xi2|qb 0  c=4.63684e-18
c1383 1091:xxarr|xi2|qb 343:ln_xarr|x_r1c0|n_61  c=1.77314e-19
c1382 1091:xxarr|xi2|qb 342:ln_xarr|x_r1c0|n_61  c=2.58857e-18
c1381 1091:xxarr|xi2|qb 1079:xxarr|xi2|q  c=2.845e-18
c1380 1091:xxarr|xi2|qb 299:ln_xarr|x_r1c0|n_62  c=2.04324e-18
cg1379 xxarr|xi2|mpu2|drn 0  c=3.95259e-17
c1378 xxarr|xi2|mpu2|drn 1056:ln_xarr|x_r1c0|n_63  c=1.26969e-18
c1377 xxarr|xi2|mpu2|drn 299:ln_xarr|x_r1c0|n_62  c=2.08119e-17
c1376 xxarr|xi2|mpu2|drn 1058:xxarr|xi2|q  c=1.77411e-19
cg1375 xxarr|xi2|mpd2|drn 0  c=3.08117e-17
c1374 xxarr|xi2|mpd2|drn 301:ln_xarr|x_r1c0|n_62  c=1.04718e-17
c1373 xxarr|xi2|mpd2|drn 1056:ln_xarr|x_r1c0|n_63  c=1.22833e-17
c1372 xxarr|xi2|mpd2|drn 1055:ln_xarr|x_r1c0|n_63  c=4.36084e-18
c1371 xxarr|xi2|mpd2|drn xxarr|xi2|mpg2|src  c=2.86429e-17
c1370 xxarr|xi2|mpd2|drn xxarr|xi2|mpg1|src  c=1.77411e-19
cg1369 1088:xxarr|xi2|qb 0  c=3.34107e-18
c1368 1088:xxarr|xi2|qb 301:ln_xarr|x_r1c0|n_62  c=2.05045e-18
c1367 1088:xxarr|xi2|qb 1056:ln_xarr|x_r1c0|n_63  c=2.93644e-18
c1366 1088:xxarr|xi2|qb 1055:ln_xarr|x_r1c0|n_63  c=1.42833e-22
cg1365 1086:xxarr|xi2|qb 0  c=4.12435e-18
cg1364 1082:xxarr|xi2|q 0  c=4.64229e-18
c1363 1082:xxarr|xi2|q 1056:ln_xarr|x_r1c0|n_63  c=1.81732e-19
c1362 1082:xxarr|xi2|q 301:ln_xarr|x_r1c0|n_62  c=1.4306e-17
c1361 1082:xxarr|xi2|q 859:wbl0  c=6.29365e-20
c1360 1082:xxarr|xi2|q 299:ln_xarr|x_r1c0|n_62  c=1.352e-17
c1359 1082:xxarr|xi2|q 300:ln_xarr|x_r1c0|n_62  c=3.98465e-17
c1358 1082:xxarr|xi2|q 343:ln_xarr|x_r1c0|n_61  c=1.00959e-17
c1357 1082:xxarr|xi2|q 591:wwl1  c=1.22939e-17
c1356 1082:xxarr|xi2|q 392:rwl1  c=1.2738e-17
cg1355 1081:xxarr|xi2|q 0  c=3.20738e-17
c1354 1081:xxarr|xi2|q 1053:ln_xarr|x_r1c0|n_63  c=1.60172e-17
c1353 1081:xxarr|xi2|q 1056:ln_xarr|x_r1c0|n_63  c=8.56291e-18
c1352 1081:xxarr|xi2|q 301:ln_xarr|x_r1c0|n_62  c=8.56737e-19
c1351 1081:xxarr|xi2|q 859:wbl0  c=1.62467e-17
c1350 1081:xxarr|xi2|q 343:ln_xarr|x_r1c0|n_61  c=2.76605e-17
c1349 1081:xxarr|xi2|q 591:wwl1  c=8.16544e-17
c1348 1081:xxarr|xi2|q 626:wwl1  c=1.78728e-18
c1347 1081:xxarr|xi2|q 592:wwl1  c=3.87169e-18
c1346 1081:xxarr|xi2|q 621:wwl1  c=2.94004e-19
c1345 1081:xxarr|xi2|q 589:wwl1  c=2.91179e-18
cg1344 1080:xxarr|xi2|q 0  c=1.9357e-17
c1343 1080:xxarr|xi2|q 397:rwl1  c=3.08344e-19
c1342 1080:xxarr|xi2|q 859:wbl0  c=6.51245e-18
c1341 1080:xxarr|xi2|q 426:rwl1  c=3.81622e-19
c1340 1080:xxarr|xi2|q 591:wwl1  c=5.35324e-17
c1339 1080:xxarr|xi2|q 392:rwl1  c=5.28618e-17
c1338 1080:xxarr|xi2|q 593:wwl1  c=9.1272e-19
cg1337 1079:xxarr|xi2|q 0  c=7.65931e-17
c1336 1079:xxarr|xi2|q 859:wbl0  c=3.1947e-17
c1335 1079:xxarr|xi2|q 299:ln_xarr|x_r1c0|n_62  c=8.12398e-19
c1334 1079:xxarr|xi2|q 396:rwl1  c=4.17368e-18
c1333 1079:xxarr|xi2|q 343:ln_xarr|x_r1c0|n_61  c=1.95052e-17
c1332 1079:xxarr|xi2|q 342:ln_xarr|x_r1c0|n_61  c=1.03838e-17
c1331 1079:xxarr|xi2|q 341:ln_xarr|x_r1c0|n_61  c=2.36305e-17
c1330 1079:xxarr|xi2|q 392:rwl1  c=7.79386e-17
c1329 1078:xxarr|xi2|q 1056:ln_xarr|x_r1c0|n_63  c=6.13076e-20
c1328 1078:xxarr|xi2|q 301:ln_xarr|x_r1c0|n_62  c=1.73008e-19
c1327 1078:xxarr|xi2|q 859:wbl0  c=9.27503e-18
c1326 1078:xxarr|xi2|q 299:ln_xarr|x_r1c0|n_62  c=1.73008e-19
c1325 1078:xxarr|xi2|q 396:rwl1  c=1.90707e-20
c1324 1078:xxarr|xi2|q 300:ln_xarr|x_r1c0|n_62  c=7.08748e-19
c1323 1078:xxarr|xi2|q 343:ln_xarr|x_r1c0|n_61  c=1.70402e-17
c1322 1078:xxarr|xi2|q 591:wwl1  c=7.95323e-18
c1321 1078:xxarr|xi2|q 392:rwl1  c=7.72508e-18
c1320 1078:xxarr|xi2|q 592:wwl1  c=1.90707e-20
c1319 1078:xxarr|xi2|q 621:wwl1  c=1.72316e-19
c1318 1078:xxarr|xi2|q 589:wwl1  c=6.84189e-19
cg1317 1064:xxarr|xi2|q 0  c=6.16709e-18
c1316 1064:xxarr|xi2|q 301:ln_xarr|x_r1c0|n_62  c=2.13866e-20
c1315 1064:xxarr|xi2|q 300:ln_xarr|x_r1c0|n_62  c=3.69271e-19
c1314 1064:xxarr|xi2|q 341:ln_xarr|x_r1c0|n_61  c=2.04324e-18
cg1313 xxarr|xi2|mpg1|src 0  c=3.14326e-17
c1312 xxarr|xi2|mpg1|src 343:ln_xarr|x_r1c0|n_61  c=4.35818e-18
c1311 xxarr|xi2|mpg1|src 1056:ln_xarr|x_r1c0|n_63  c=1.23294e-17
c1310 xxarr|xi2|mpg1|src 834:wbl0  c=2.8718e-17
c1309 xxarr|xi2|mpg1|src 1053:ln_xarr|x_r1c0|n_63  c=1.04744e-17
cg1308 1061:xxarr|xi2|q 0  c=1.10827e-18
c1307 1061:xxarr|xi2|q 1056:ln_xarr|x_r1c0|n_63  c=2.91313e-18
c1306 1061:xxarr|xi2|q 1055:ln_xarr|x_r1c0|n_63  c=2.05046e-18
cg1305 1058:xxarr|xi2|q 0  c=3.47913e-17
c1304 1058:xxarr|xi2|q 1056:ln_xarr|x_r1c0|n_63  c=1.26969e-18
c1303 1058:xxarr|xi2|q 341:ln_xarr|x_r1c0|n_61  c=2.08182e-17
cg1302 1057:ln_xarr|x_r1c0|n_63 0  c=1.12779e-17
c1301 1057:ln_xarr|x_r1c0|n_63 859:wbl0  c=5.6761e-20
c1300 1057:ln_xarr|x_r1c0|n_63 626:wwl1  c=3.51697e-17
c1299 1057:ln_xarr|x_r1c0|n_63 621:wwl1  c=1.95231e-18
cg1298 1056:ln_xarr|x_r1c0|n_63 0  c=9.64049e-17
c1297 1056:ln_xarr|x_r1c0|n_63 301:ln_xarr|x_r1c0|n_62  c=1.11969e-17
c1296 1056:ln_xarr|x_r1c0|n_63 859:wbl0  c=7.3067e-18
c1295 1056:ln_xarr|x_r1c0|n_63 300:ln_xarr|x_r1c0|n_62  c=1.18936e-19
c1294 1056:ln_xarr|x_r1c0|n_63 343:ln_xarr|x_r1c0|n_61  c=1.11273e-17
c1293 1056:ln_xarr|x_r1c0|n_63 616:wwl1  c=2.90509e-18
c1292 1056:ln_xarr|x_r1c0|n_63 342:ln_xarr|x_r1c0|n_61  c=3.81442e-19
c1291 1056:ln_xarr|x_r1c0|n_63 626:wwl1  c=1.64483e-17
c1290 1056:ln_xarr|x_r1c0|n_63 834:wbl0  c=1.08947e-17
c1289 1056:ln_xarr|x_r1c0|n_63 589:wwl1  c=2.84981e-18
c1288 1056:ln_xarr|x_r1c0|n_63 836:wbl0  c=8.33292e-19
cg1287 1055:ln_xarr|x_r1c0|n_63 0  c=1.46285e-17
c1286 1055:ln_xarr|x_r1c0|n_63 xxarr|xi2|mpg2|src  c=2.08714e-17
c1285 1055:ln_xarr|x_r1c0|n_63 301:ln_xarr|x_r1c0|n_62  c=1.22014e-17
c1284 1055:ln_xarr|x_r1c0|n_63 343:ln_xarr|x_r1c0|n_61  c=4.72549e-19
c1283 1055:ln_xarr|x_r1c0|n_63 591:wwl1  c=6.22962e-19
c1282 1055:ln_xarr|x_r1c0|n_63 832:wblb0  c=2.16006e-17
cg1281 1053:ln_xarr|x_r1c0|n_63 0  c=3.16049e-18
c1280 1053:ln_xarr|x_r1c0|n_63 301:ln_xarr|x_r1c0|n_62  c=3.54163e-19
c1279 1053:ln_xarr|x_r1c0|n_63 859:wbl0  c=1.83161e-17
c1278 1053:ln_xarr|x_r1c0|n_63 343:ln_xarr|x_r1c0|n_61  c=1.22427e-17
c1277 1053:ln_xarr|x_r1c0|n_63 591:wwl1  c=6.22962e-19
c1276 1053:ln_xarr|x_r1c0|n_63 626:wwl1  c=6.27637e-18
c1275 1053:ln_xarr|x_r1c0|n_63 834:wbl0  c=1.42757e-17
c1274 1053:ln_xarr|x_r1c0|n_63 621:wwl1  c=2.14164e-19
cg1273 1052:ln_xarr|x_r0c0|n_65 0  c=4.2e-18
c1272 1052:ln_xarr|x_r0c0|n_65 573:rbl0  c=1.71835e-18
c1271 1052:ln_xarr|x_r0c0|n_65 912:rwl0  c=1.13381e-17
c1270 1052:ln_xarr|x_r0c0|n_65 303:ln_xarr|x_r0c0|n_64  c=2.77122e-18
cg1269 1051:ln_xarr|x_r0c0|n_65 0  c=8.04614e-18
c1268 1051:ln_xarr|x_r0c0|n_65 863:xxarr|xi0|net5  c=1.40947e-17
c1267 1051:ln_xarr|x_r0c0|n_65 xxarr|xi0|mra1|drn  c=4.35855e-18
c1266 1051:ln_xarr|x_r0c0|n_65 573:rbl0  c=2.15645e-17
c1265 1051:ln_xarr|x_r0c0|n_65 xxarr|xi0|mra2|drn  c=2.07705e-17
c1264 1051:ln_xarr|x_r0c0|n_65 303:ln_xarr|x_r0c0|n_64  c=1.2147e-17
cg1263 1050:ln_xarr|x_r0c0|n_65 0  c=9.75448e-18
c1262 1050:ln_xarr|x_r0c0|n_65 863:xxarr|xi0|net5  c=1.11545e-18
c1261 1050:ln_xarr|x_r0c0|n_65 xxarr|xi0|mra1|drn  c=1.61315e-18
c1260 1050:ln_xarr|x_r0c0|n_65 875:rwl0  c=3.82601e-18
c1259 1050:ln_xarr|x_r0c0|n_65 573:rbl0  c=4.35255e-17
c1258 1050:ln_xarr|x_r0c0|n_65 912:rwl0  c=4.62273e-17
c1257 1050:ln_xarr|x_r0c0|n_65 303:ln_xarr|x_r0c0|n_64  c=4.09833e-17
cg1256 1049:ln_xarr|x_r0c0|n_63 0  c=9.2129e-18
c1255 1049:ln_xarr|x_r0c0|n_63 678:wwl0  c=3.34046e-17
c1254 1049:ln_xarr|x_r0c0|n_63 859:wbl0  c=4.25465e-18
c1253 1049:ln_xarr|x_r0c0|n_63 674:wwl0  c=1.95231e-18
c1252 1049:ln_xarr|x_r0c0|n_63 854:wbl0  c=8.27461e-19
cg1251 1048:ln_xarr|x_r0c0|n_63 0  c=8.67174e-17
c1250 1048:ln_xarr|x_r0c0|n_63 824:wblb0  c=1.68182e-18
c1249 1048:ln_xarr|x_r0c0|n_63 xxarr|xi0|mpu2|drn  c=1.26969e-18
c1248 1048:ln_xarr|x_r0c0|n_63 857:wbl0  c=5.18639e-18
c1247 1048:ln_xarr|x_r0c0|n_63 819:wblb0  c=2.60254e-18
c1246 1048:ln_xarr|x_r0c0|n_63 936:xxarr|xi0|q  c=8.21779e-18
c1245 1048:ln_xarr|x_r0c0|n_63 937:xxarr|xi0|q  c=1.76544e-20
c1244 1048:ln_xarr|x_r0c0|n_63 833:wblb0  c=1.8053e-19
c1243 1048:ln_xarr|x_r0c0|n_63 969:xxarr|xi0|qb  c=7.56926e-18
c1242 1048:ln_xarr|x_r0c0|n_63 859:wbl0  c=2.89728e-17
c1241 1048:ln_xarr|x_r0c0|n_63 916:xxarr|xi0|q  c=1.26969e-18
c1240 1048:ln_xarr|x_r0c0|n_63 828:wblb0  c=1.27415e-19
c1239 1048:ln_xarr|x_r0c0|n_63 854:wbl0  c=4.9626e-18
c1238 1048:ln_xarr|x_r0c0|n_63 315:ln_xarr|x_r0c0|n_62  c=5.35821e-18
c1237 1048:ln_xarr|x_r0c0|n_63 939:xxarr|xi0|q  c=1.81732e-19
c1236 1048:ln_xarr|x_r0c0|n_63 316:ln_xarr|x_r0c0|n_62  c=1.18936e-19
c1235 1048:ln_xarr|x_r0c0|n_63 xxarr|xi0|mpg1|src  c=1.27288e-17
c1234 1048:ln_xarr|x_r0c0|n_63 xxwd0|xi1|mm0|drn  c=6.41179e-19
c1233 1048:ln_xarr|x_r0c0|n_63 xxarr|xi0|mpd2|drn  c=1.23422e-17
c1232 1048:ln_xarr|x_r0c0|n_63 xxwd0|xi1|mm1|gate  c=2.01946e-18
c1231 1048:ln_xarr|x_r0c0|n_63 xxwd0|xi1|mm1|drn  c=1.89954e-18
c1230 1048:ln_xarr|x_r0c0|n_63 933:xxarr|xi0|q  c=2.91996e-18
c1229 1048:ln_xarr|x_r0c0|n_63 832:wblb0  c=7.55286e-18
c1228 1048:ln_xarr|x_r0c0|n_63 678:wwl0  c=1.3077e-17
c1227 1048:ln_xarr|x_r0c0|n_63 834:wbl0  c=8.33292e-19
c1226 1048:ln_xarr|x_r0c0|n_63 866:ln_xarr|x_r0c0|n_61  c=3.81442e-19
c1225 1048:ln_xarr|x_r0c0|n_63 975:xxarr|xi0|qb  c=7.61222e-20
c1224 1048:ln_xarr|x_r0c0|n_63 964:xxarr|xi0|qb  c=2.68111e-18
c1223 1048:ln_xarr|x_r0c0|n_63 864:ln_xarr|x_r0c0|n_61  c=1.13655e-17
c1222 1048:ln_xarr|x_r0c0|n_63 668:wwl0  c=2.60239e-18
c1221 1048:ln_xarr|x_r0c0|n_63 836:wbl0  c=1.13631e-17
cg1220 1047:ln_xarr|x_r0c0|n_63 0  c=1.05854e-17
c1219 1047:ln_xarr|x_r0c0|n_63 xxarr|xi2|mpg2|src  c=5.87933e-21
c1218 1047:ln_xarr|x_r0c0|n_63 972:xxarr|xi0|qb  c=9.32816e-20
c1217 1047:ln_xarr|x_r0c0|n_63 969:xxarr|xi0|qb  c=1.3751e-17
c1216 1047:ln_xarr|x_r0c0|n_63 971:xxarr|xi0|qb  c=3.47766e-19
c1215 1047:ln_xarr|x_r0c0|n_63 315:ln_xarr|x_r0c0|n_62  c=1.21109e-17
c1214 1047:ln_xarr|x_r0c0|n_63 xxarr|xi0|mpg2|src  c=2.08714e-17
c1213 1047:ln_xarr|x_r0c0|n_63 xxarr|xi0|mpd2|drn  c=4.36084e-18
c1212 1047:ln_xarr|x_r0c0|n_63 933:xxarr|xi0|q  c=2.05046e-18
c1211 1047:ln_xarr|x_r0c0|n_63 832:wblb0  c=3.17763e-17
c1210 1047:ln_xarr|x_r0c0|n_63 641:wwl0  c=6.65274e-19
c1209 1047:ln_xarr|x_r0c0|n_63 964:xxarr|xi0|qb  c=1.42833e-22
c1208 1047:ln_xarr|x_r0c0|n_63 864:ln_xarr|x_r0c0|n_61  c=3.54163e-19
cg1207 1045:ln_xarr|x_r0c0|n_63 0  c=3.5833e-18
c1206 1045:ln_xarr|x_r0c0|n_63 819:wblb0  c=2.9342e-20
c1205 1045:ln_xarr|x_r0c0|n_63 936:xxarr|xi0|q  c=1.70399e-17
c1204 1045:ln_xarr|x_r0c0|n_63 937:xxarr|xi0|q  c=1.00699e-18
c1203 1045:ln_xarr|x_r0c0|n_63 859:wbl0  c=2.78445e-17
c1202 1045:ln_xarr|x_r0c0|n_63 315:ln_xarr|x_r0c0|n_62  c=3.54163e-19
c1201 1045:ln_xarr|x_r0c0|n_63 xxarr|xi0|mpg1|src  c=1.04744e-17
c1200 1045:ln_xarr|x_r0c0|n_63 xxwd0|xi1|mm1|gate  c=2.4017e-20
c1199 1045:ln_xarr|x_r0c0|n_63 933:xxarr|xi0|q  c=1.42833e-22
c1198 1045:ln_xarr|x_r0c0|n_63 678:wwl0  c=3.48815e-18
c1197 1045:ln_xarr|x_r0c0|n_63 834:wbl0  c=5.87933e-21
c1196 1045:ln_xarr|x_r0c0|n_63 641:wwl0  c=6.65274e-19
c1195 1045:ln_xarr|x_r0c0|n_63 964:xxarr|xi0|qb  c=2.05046e-18
c1194 1045:ln_xarr|x_r0c0|n_63 674:wwl0  c=2.14164e-19
c1193 1045:ln_xarr|x_r0c0|n_63 864:ln_xarr|x_r0c0|n_61  c=1.42346e-17
c1192 1045:ln_xarr|x_r0c0|n_63 836:wbl0  c=1.42757e-17
cg1191 1044:xxarr|xi2|net5 0  c=4.19392e-17
c1190 1044:xxarr|xi2|net5 306:ln_xarr|x_r1c0|n_64  c=2.99821e-19
c1189 1044:xxarr|xi2|net5 624:wwl1  c=1.72923e-18
c1188 1044:xxarr|xi2|net5 625:wwl1  c=8.87316e-19
c1187 1044:xxarr|xi2|net5 573:rbl0  c=1.45333e-17
c1186 1044:xxarr|xi2|net5 591:wwl1  c=3.21848e-17
c1185 1044:xxarr|xi2|net5 571:rbl0  c=3.55917e-18
c1184 1044:xxarr|xi2|net5 307:ln_xarr|x_r1c0|n_64  c=1.63523e-17
cg1183 xxarr|xi2|mra1|drn 0  c=3.10373e-17
c1182 xxarr|xi2|mra1|drn 307:ln_xarr|x_r1c0|n_64  c=1.04514e-17
c1181 xxarr|xi2|mra1|drn 571:rbl0  c=1.22609e-18
c1180 xxarr|xi2|mra1|drn 306:ln_xarr|x_r1c0|n_64  c=3.72463e-19
c1179 xxarr|xi2|mra1|drn xxarr|xi2|mra2|drn  c=2.8718e-17
cg1178 1041:xxarr|xi1|qb 0  c=3.23071e-18
c1177 1041:xxarr|xi1|qb 913:ln_xarr|x_r0c1|n_61  c=6.2621e-18
c1176 1041:xxarr|xi1|qb 908:rwl0  c=2.23778e-17
c1175 1041:xxarr|xi1|qb 1005:xxarr|xi1|q  c=2.1131e-18
c1174 1041:xxarr|xi1|qb 320:ln_xarr|x_r0c1|n_62  c=1.52234e-18
c1173 1041:xxarr|xi1|qb 319:ln_xarr|x_r0c1|n_62  c=3.5291e-19
c1172 1041:xxarr|xi1|qb 1004:xxarr|xi1|q  c=1.23943e-18
c1171 1041:xxarr|xi1|qb 1006:xxarr|xi1|q  c=3.21778e-18
c1170 1041:xxarr|xi1|qb 915:ln_xarr|x_r0c1|n_61  c=1.57924e-17
cg1169 1040:xxarr|xi1|qb 0  c=7.60669e-17
c1168 1040:xxarr|xi1|qb 311:ln_xarr|x_r0c1|n_64  c=1.14611e-20
c1167 1040:xxarr|xi1|qb 761:wblb1  c=1.33428e-17
c1166 1040:xxarr|xi1|qb 320:ln_xarr|x_r0c1|n_62  c=2.18148e-17
c1165 1040:xxarr|xi1|qb 985:xxarr|xi1|q  c=1.79186e-18
c1164 1040:xxarr|xi1|qb 914:ln_xarr|x_r0c1|n_61  c=6.65085e-20
c1163 1040:xxarr|xi1|qb 1006:xxarr|xi1|q  c=6.57226e-19
cg1162 1039:xxarr|xi1|qb 0  c=3.69545e-18
c1161 1039:xxarr|xi1|qb 312:ln_xarr|x_r0c1|n_64  c=7.28183e-18
c1160 1039:xxarr|xi1|qb 311:ln_xarr|x_r0c1|n_64  c=1.53949e-17
c1159 1039:xxarr|xi1|qb 908:rwl0  c=2.38502e-17
c1158 1039:xxarr|xi1|qb 676:wwl0  c=1.37968e-18
c1157 1039:xxarr|xi1|qb 761:wblb1  c=9.70873e-19
c1156 1039:xxarr|xi1|qb 911:rwl0  c=3.33313e-18
c1155 1039:xxarr|xi1|qb 753:wblb1  c=1.66779e-25
c1154 1038:xxarr|xi1|qb 913:ln_xarr|x_r0c1|n_61  c=1.45079e-19
c1153 1038:xxarr|xi1|qb 311:ln_xarr|x_r0c1|n_64  c=2.37089e-19
c1152 1038:xxarr|xi1|qb 908:rwl0  c=7.85861e-18
c1151 1038:xxarr|xi1|qb 676:wwl0  c=2.47382e-19
c1150 1038:xxarr|xi1|qb 1005:xxarr|xi1|q  c=1.79816e-19
c1149 1038:xxarr|xi1|qb 665:wwl0  c=2.77313e-19
c1148 1038:xxarr|xi1|qb 761:wblb1  c=7.61319e-18
c1147 1038:xxarr|xi1|qb 320:ln_xarr|x_r0c1|n_62  c=1.93171e-17
c1146 1038:xxarr|xi1|qb 1004:xxarr|xi1|q  c=4.58554e-19
c1145 1038:xxarr|xi1|qb 914:ln_xarr|x_r0c1|n_61  c=1.45078e-19
c1144 1038:xxarr|xi1|qb 1006:xxarr|xi1|q  c=4.34902e-20
c1143 1038:xxarr|xi1|qb 915:ln_xarr|x_r0c1|n_61  c=4.28158e-19
cg1142 1037:xxarr|xi1|qb 0  c=1.65751e-17
c1141 1037:xxarr|xi1|qb 311:ln_xarr|x_r0c1|n_64  c=5.09614e-17
c1140 1037:xxarr|xi1|qb 908:rwl0  c=1.36932e-18
c1139 1037:xxarr|xi1|qb 676:wwl0  c=1.03365e-19
c1138 1037:xxarr|xi1|qb 761:wblb1  c=4.56501e-18
c1137 1037:xxarr|xi1|qb 911:rwl0  c=4.66987e-18
cg1136 1036:xxarr|xi1|qb 0  c=7.62573e-17
c1135 1036:xxarr|xi1|qb 908:rwl0  c=1.0078e-16
c1134 1036:xxarr|xi1|qb 676:wwl0  c=3.56959e-18
c1133 1036:xxarr|xi1|qb 1005:xxarr|xi1|q  c=3.57297e-19
c1132 1036:xxarr|xi1|qb 761:wblb1  c=9.46715e-17
c1131 1036:xxarr|xi1|qb 911:rwl0  c=3.70442e-18
c1130 1036:xxarr|xi1|qb 1004:xxarr|xi1|q  c=3.61246e-18
c1129 1036:xxarr|xi1|qb 1006:xxarr|xi1|q  c=1.09512e-17
cg1128 1035:xxarr|xi1|qb 0  c=3.20972e-17
c1127 1035:xxarr|xi1|qb 312:ln_xarr|x_r0c1|n_64  c=1.01395e-18
c1126 1035:xxarr|xi1|qb 913:ln_xarr|x_r0c1|n_61  c=1.48536e-18
c1125 1035:xxarr|xi1|qb 1002:xxarr|xi1|q  c=6.74098e-19
c1124 1035:xxarr|xi1|qb 311:ln_xarr|x_r0c1|n_64  c=1.14611e-20
c1123 1035:xxarr|xi1|qb 908:rwl0  c=8.19196e-17
c1122 1035:xxarr|xi1|qb 676:wwl0  c=1.01349e-16
c1121 1035:xxarr|xi1|qb 1005:xxarr|xi1|q  c=2.91224e-17
c1120 1035:xxarr|xi1|qb 665:wwl0  c=5.69536e-19
c1119 1035:xxarr|xi1|qb 999:xxarr|xi1|q  c=3.64732e-18
c1118 1035:xxarr|xi1|qb 761:wblb1  c=3.12108e-17
c1117 1035:xxarr|xi1|qb 320:ln_xarr|x_r0c1|n_62  c=1.89392e-17
c1116 1035:xxarr|xi1|qb 911:rwl0  c=3.17646e-23
c1115 1035:xxarr|xi1|qb 318:ln_xarr|x_r0c1|n_62  c=3.18446e-17
c1114 1035:xxarr|xi1|qb 319:ln_xarr|x_r0c1|n_62  c=1.02803e-17
c1113 1035:xxarr|xi1|qb 1004:xxarr|xi1|q  c=8.01319e-18
c1112 1035:xxarr|xi1|qb 759:wblb1  c=1.43419e-18
c1111 1035:xxarr|xi1|qb 1006:xxarr|xi1|q  c=4.2217e-19
c1110 1035:xxarr|xi1|qb 1003:xxarr|xi1|q  c=1.29779e-18
cg1109 1033:xxarr|xi1|qb 0  c=1.21913e-17
c1108 1033:xxarr|xi1|qb 908:rwl0  c=1.1647e-18
c1107 1033:xxarr|xi1|qb 1005:xxarr|xi1|q  c=9.70333e-20
c1106 1033:xxarr|xi1|qb 761:wblb1  c=9.95195e-21
c1105 1033:xxarr|xi1|qb 320:ln_xarr|x_r0c1|n_62  c=1.00134e-17
c1104 1033:xxarr|xi1|qb 319:ln_xarr|x_r0c1|n_62  c=4.43378e-20
c1103 1033:xxarr|xi1|qb 1004:xxarr|xi1|q  c=5.51253e-20
c1102 1033:xxarr|xi1|qb 914:ln_xarr|x_r0c1|n_61  c=6.70057e-18
c1101 1033:xxarr|xi1|qb 1006:xxarr|xi1|q  c=2.07886e-17
c1100 1033:xxarr|xi1|qb 915:ln_xarr|x_r0c1|n_61  c=4.70423e-17
cg1099 1030:xxarr|xi1|qb 0  c=3.29575e-18
c1098 1030:xxarr|xi1|qb 1002:xxarr|xi1|q  c=6.96305e-19
c1097 1030:xxarr|xi1|qb 318:ln_xarr|x_r0c1|n_62  c=2.05045e-18
c1096 1030:xxarr|xi1|qb 914:ln_xarr|x_r0c1|n_61  c=1.54693e-20
c1095 1030:xxarr|xi1|qb 1003:xxarr|xi1|q  c=2.90803e-18
c1094 1030:xxarr|xi1|qb 915:ln_xarr|x_r0c1|n_61  c=2.55086e-19
cg1093 1015:xxarr|xi1|qb 0  c=4.70183e-18
c1092 1015:xxarr|xi1|qb 320:ln_xarr|x_r0c1|n_62  c=2.04324e-18
cg1091 xxarr|xi1|mpd2|drn 0  c=3.00051e-17
c1090 xxarr|xi1|mpd2|drn 318:ln_xarr|x_r0c1|n_62  c=1.04718e-17
c1089 xxarr|xi1|mpd2|drn xxarr|xi1|mpg2|src  c=2.86429e-17
c1088 xxarr|xi1|mpd2|drn xxarr|xi1|mpg1|src  c=1.77411e-19
cg1087 xxarr|xi1|mpu2|drn 0  c=3.76211e-17
c1086 xxarr|xi1|mpu2|drn 320:ln_xarr|x_r0c1|n_62  c=2.08182e-17
c1085 xxarr|xi1|mpu2|drn 982:xxarr|xi1|q  c=1.77411e-19
cg1084 1010:xxarr|xi1|qb 0  c=2.20043e-18
c1083 1010:xxarr|xi1|qb 311:ln_xarr|x_r0c1|n_64  c=3.0147e-19
cg1082 1006:xxarr|xi1|q 0  c=8.01282e-17
c1081 1006:xxarr|xi1|q 913:ln_xarr|x_r0c1|n_61  c=1.94492e-17
c1080 1006:xxarr|xi1|q 788:wbl1  c=3.17283e-17
c1079 1006:xxarr|xi1|q 908:rwl0  c=7.81814e-17
c1078 1006:xxarr|xi1|q 320:ln_xarr|x_r0c1|n_62  c=8.12398e-19
c1077 1006:xxarr|xi1|q 867:rwl0  c=3.91791e-18
c1076 1006:xxarr|xi1|q 914:ln_xarr|x_r0c1|n_61  c=2.06826e-17
c1075 1006:xxarr|xi1|q 915:ln_xarr|x_r0c1|n_61  c=1.03653e-17
cg1074 1005:xxarr|xi1|q 0  c=4.66803e-18
c1073 1005:xxarr|xi1|q 913:ln_xarr|x_r0c1|n_61  c=1.00959e-17
c1072 1005:xxarr|xi1|q 788:wbl1  c=6.29365e-20
c1071 1005:xxarr|xi1|q 908:rwl0  c=1.27549e-17
c1070 1005:xxarr|xi1|q 676:wwl0  c=1.23577e-17
c1069 1005:xxarr|xi1|q 320:ln_xarr|x_r0c1|n_62  c=1.352e-17
c1068 1005:xxarr|xi1|q 318:ln_xarr|x_r0c1|n_62  c=1.43359e-17
c1067 1005:xxarr|xi1|q 319:ln_xarr|x_r0c1|n_62  c=3.98465e-17
cg1066 1004:xxarr|xi1|q 0  c=1.99965e-17
c1065 1004:xxarr|xi1|q 788:wbl1  c=6.50506e-18
c1064 1004:xxarr|xi1|q 908:rwl0  c=5.28618e-17
c1063 1004:xxarr|xi1|q 676:wwl0  c=5.35251e-17
cg1062 1003:xxarr|xi1|q 0  c=3.17238e-17
c1061 1003:xxarr|xi1|q 913:ln_xarr|x_r0c1|n_61  c=3.05801e-17
c1060 1003:xxarr|xi1|q 781:wbl1  c=5.05435e-19
c1059 1003:xxarr|xi1|q 788:wbl1  c=1.64366e-17
c1058 1003:xxarr|xi1|q 676:wwl0  c=8.53947e-17
c1057 1003:xxarr|xi1|q 776:wbl1  c=4.13639e-19
c1056 1003:xxarr|xi1|q 677:wwl0  c=1.78728e-18
c1055 1003:xxarr|xi1|q 666:wwl0  c=2.91179e-18
c1054 1003:xxarr|xi1|q 318:ln_xarr|x_r0c1|n_62  c=8.56737e-19
c1053 1003:xxarr|xi1|q 673:wwl0  c=2.94004e-19
c1052 1003:xxarr|xi1|q 785:wbl1  c=4.19982e-19
c1051 1002:xxarr|xi1|q 913:ln_xarr|x_r0c1|n_61  c=1.69637e-17
c1050 1002:xxarr|xi1|q 788:wbl1  c=9.29713e-18
c1049 1002:xxarr|xi1|q 908:rwl0  c=7.72508e-18
c1048 1002:xxarr|xi1|q 676:wwl0  c=7.95323e-18
c1047 1002:xxarr|xi1|q 320:ln_xarr|x_r0c1|n_62  c=1.73008e-19
c1046 1002:xxarr|xi1|q 666:wwl0  c=7.23048e-19
c1045 1002:xxarr|xi1|q 318:ln_xarr|x_r0c1|n_62  c=1.73008e-19
c1044 1002:xxarr|xi1|q 673:wwl0  c=1.72316e-19
c1043 1002:xxarr|xi1|q 319:ln_xarr|x_r0c1|n_62  c=7.08748e-19
c1042 1002:xxarr|xi1|q 785:wbl1  c=8.46451e-20
c1041 1002:xxarr|xi1|q 867:rwl0  c=1.60373e-20
cg1040 999:xxarr|xi1|q 0  c=3.11554e-18
c1039 999:xxarr|xi1|q 320:ln_xarr|x_r0c1|n_62  c=5.54833e-20
c1038 999:xxarr|xi1|q 319:ln_xarr|x_r0c1|n_62  c=1.18022e-18
c1037 999:xxarr|xi1|q 913:ln_xarr|x_r0c1|n_61  c=2.05045e-18
cg1036 xxarr|xi1|mpg1|src 0  c=3.13934e-17
c1035 xxarr|xi1|mpg1|src xxwd1|xi1|mm1|drn  c=3.24526e-19
c1034 xxarr|xi1|mpg1|src 765:wbl1  c=2.8718e-17
c1033 xxarr|xi1|mpg1|src 913:ln_xarr|x_r0c1|n_61  c=1.04718e-17
cg1032 985:xxarr|xi1|q 0  c=3.49197e-18
cg1031 982:xxarr|xi1|q 0  c=3.51313e-17
c1030 982:xxarr|xi1|q 914:ln_xarr|x_r0c1|n_61  c=1.4273e-17
cg1029 981:ln_xarr|x_r1c1|n_61 0  c=4.27366e-17
c1028 981:ln_xarr|x_r1c1|n_61 310:ln_xarr|x_r1c1|n_62  c=2.328e-17
c1027 981:ln_xarr|x_r1c1|n_61 308:ln_xarr|x_r1c1|n_62  c=1.54774e-17
c1026 981:ln_xarr|x_r1c1|n_61 309:ln_xarr|x_r1c1|n_62  c=1.59518e-17
cg1025 980:ln_xarr|x_r1c1|n_61 0  c=1.72865e-17
c1024 980:ln_xarr|x_r1c1|n_61 308:ln_xarr|x_r1c1|n_62  c=2.13518e-17
cg1023 979:ln_xarr|x_r1c1|n_61 0  c=4.4775e-17
c1022 979:ln_xarr|x_r1c1|n_61 308:ln_xarr|x_r1c1|n_62  c=1.38757e-17
cg1021 978:xxarr|xi1|net5 0  c=4.39675e-17
c1020 978:xxarr|xi1|net5 312:ln_xarr|x_r0c1|n_64  c=1.63523e-17
c1019 978:xxarr|xi1|net5 311:ln_xarr|x_r0c1|n_64  c=2.99821e-19
c1018 978:xxarr|xi1|net5 716:rbl1  c=1.47043e-17
c1017 978:xxarr|xi1|net5 676:wwl0  c=3.38573e-17
cg1016 xxarr|xi1|mra1|drn 0  c=3.21478e-17
c1015 xxarr|xi1|mra1|drn 312:ln_xarr|x_r0c1|n_64  c=1.04514e-17
c1014 xxarr|xi1|mra1|drn 311:ln_xarr|x_r0c1|n_64  c=3.72463e-19
c1013 xxarr|xi1|mra1|drn xxarr|xi1|mra2|drn  c=2.8718e-17
cg1012 975:xxarr|xi0|qb 0  c=3.23071e-18
c1011 975:xxarr|xi0|qb 940:xxarr|xi0|q  c=3.21778e-18
c1010 975:xxarr|xi0|qb 938:xxarr|xi0|q  c=1.23943e-18
c1009 975:xxarr|xi0|qb 317:ln_xarr|x_r0c0|n_62  c=1.52234e-18
c1008 975:xxarr|xi0|qb 939:xxarr|xi0|q  c=2.1131e-18
c1007 975:xxarr|xi0|qb 316:ln_xarr|x_r0c0|n_62  c=3.5291e-19
c1006 975:xxarr|xi0|qb 867:rwl0  c=2.23585e-17
c1005 975:xxarr|xi0|qb 866:ln_xarr|x_r0c0|n_61  c=1.57924e-17
c1004 975:xxarr|xi0|qb 864:ln_xarr|x_r0c0|n_61  c=6.2621e-18
cg1003 974:xxarr|xi0|qb 0  c=7.60669e-17
c1002 974:xxarr|xi0|qb 302:ln_xarr|x_r0c0|n_64  c=1.14611e-20
c1001 974:xxarr|xi0|qb 940:xxarr|xi0|q  c=6.57226e-19
c1000 974:xxarr|xi0|qb 317:ln_xarr|x_r0c0|n_62  c=2.18003e-17
c999 974:xxarr|xi0|qb 919:xxarr|xi0|q  c=1.79663e-18
c998 974:xxarr|xi0|qb 865:ln_xarr|x_r0c0|n_61  c=6.65085e-20
c997 974:xxarr|xi0|qb 832:wblb0  c=1.33428e-17
cg996 973:xxarr|xi0|qb 0  c=3.69965e-18
c995 973:xxarr|xi0|qb 302:ln_xarr|x_r0c0|n_64  c=1.53939e-17
c994 973:xxarr|xi0|qb 825:wblb0  c=1.66779e-25
c993 973:xxarr|xi0|qb 867:rwl0  c=2.38299e-17
c992 973:xxarr|xi0|qb 832:wblb0  c=9.70873e-19
c991 973:xxarr|xi0|qb 641:wwl0  c=1.37968e-18
c990 973:xxarr|xi0|qb 912:rwl0  c=3.33313e-18
c989 973:xxarr|xi0|qb 303:ln_xarr|x_r0c0|n_64  c=7.2778e-18
cg988 972:xxarr|xi0|qb 0  c=7.54467e-17
c987 972:xxarr|xi0|qb 643:wwl0  c=1.37042e-18
c986 972:xxarr|xi0|qb 940:xxarr|xi0|q  c=1.1042e-17
c985 972:xxarr|xi0|qb 938:xxarr|xi0|q  c=3.61246e-18
c984 972:xxarr|xi0|qb 939:xxarr|xi0|q  c=3.57297e-19
c983 972:xxarr|xi0|qb 909:rwl0  c=5.26683e-19
c982 972:xxarr|xi0|qb 832:wblb0  c=9.46715e-17
c981 972:xxarr|xi0|qb 867:rwl0  c=1.0078e-16
c980 972:xxarr|xi0|qb 641:wwl0  c=3.56959e-18
c979 972:xxarr|xi0|qb 912:rwl0  c=3.71364e-18
c978 971:xxarr|xi0|qb 302:ln_xarr|x_r0c0|n_64  c=2.37089e-19
c977 971:xxarr|xi0|qb 940:xxarr|xi0|q  c=4.34902e-20
c976 971:xxarr|xi0|qb 938:xxarr|xi0|q  c=4.58554e-19
c975 971:xxarr|xi0|qb 317:ln_xarr|x_r0c0|n_62  c=1.9305e-17
c974 971:xxarr|xi0|qb 939:xxarr|xi0|q  c=1.79816e-19
c973 971:xxarr|xi0|qb 667:wwl0  c=2.77313e-19
c972 971:xxarr|xi0|qb 865:ln_xarr|x_r0c0|n_61  c=1.45078e-19
c971 971:xxarr|xi0|qb 832:wblb0  c=7.61319e-18
c970 971:xxarr|xi0|qb 867:rwl0  c=7.85861e-18
c969 971:xxarr|xi0|qb 641:wwl0  c=2.47382e-19
c968 971:xxarr|xi0|qb 866:ln_xarr|x_r0c0|n_61  c=4.28158e-19
c967 971:xxarr|xi0|qb 864:ln_xarr|x_r0c0|n_61  c=1.45078e-19
cg966 970:xxarr|xi0|qb 0  c=1.72619e-17
c965 970:xxarr|xi0|qb 302:ln_xarr|x_r0c0|n_64  c=5.09491e-17
c964 970:xxarr|xi0|qb 867:rwl0  c=1.36932e-18
c963 970:xxarr|xi0|qb 832:wblb0  c=4.56501e-18
c962 970:xxarr|xi0|qb 641:wwl0  c=1.03365e-19
c961 970:xxarr|xi0|qb 912:rwl0  c=4.66987e-18
cg960 969:xxarr|xi0|qb 0  c=3.14465e-17
c959 969:xxarr|xi0|qb 302:ln_xarr|x_r0c0|n_64  c=1.14611e-20
c958 969:xxarr|xi0|qb 940:xxarr|xi0|q  c=4.22849e-19
c957 969:xxarr|xi0|qb 936:xxarr|xi0|q  c=1.29857e-18
c956 969:xxarr|xi0|qb 937:xxarr|xi0|q  c=6.74098e-19
c955 969:xxarr|xi0|qb 938:xxarr|xi0|q  c=7.91686e-18
c954 969:xxarr|xi0|qb 317:ln_xarr|x_r0c0|n_62  c=1.89393e-17
c953 969:xxarr|xi0|qb 828:wblb0  c=1.43419e-18
c952 969:xxarr|xi0|qb 315:ln_xarr|x_r0c0|n_62  c=3.18448e-17
c951 969:xxarr|xi0|qb 939:xxarr|xi0|q  c=2.91224e-17
c950 969:xxarr|xi0|qb 316:ln_xarr|x_r0c0|n_62  c=1.02803e-17
c949 969:xxarr|xi0|qb 667:wwl0  c=5.69536e-19
c948 969:xxarr|xi0|qb 933:xxarr|xi0|q  c=3.64732e-18
c947 969:xxarr|xi0|qb 832:wblb0  c=3.12108e-17
c946 969:xxarr|xi0|qb 867:rwl0  c=8.19171e-17
c945 969:xxarr|xi0|qb 641:wwl0  c=1.01345e-16
c944 969:xxarr|xi0|qb 912:rwl0  c=3.17646e-23
c943 969:xxarr|xi0|qb 864:ln_xarr|x_r0c0|n_61  c=1.48536e-18
c942 969:xxarr|xi0|qb 303:ln_xarr|x_r0c0|n_64  c=1.01395e-18
cg941 967:xxarr|xi0|qb 0  c=1.21913e-17
c940 967:xxarr|xi0|qb 940:xxarr|xi0|q  c=2.07886e-17
c939 967:xxarr|xi0|qb 938:xxarr|xi0|q  c=5.51253e-20
c938 967:xxarr|xi0|qb 317:ln_xarr|x_r0c0|n_62  c=1.00134e-17
c937 967:xxarr|xi0|qb 939:xxarr|xi0|q  c=9.70333e-20
c936 967:xxarr|xi0|qb 316:ln_xarr|x_r0c0|n_62  c=4.43378e-20
c935 967:xxarr|xi0|qb 865:ln_xarr|x_r0c0|n_61  c=6.70057e-18
c934 967:xxarr|xi0|qb 867:rwl0  c=1.1647e-18
c933 967:xxarr|xi0|qb 832:wblb0  c=9.95195e-21
c932 967:xxarr|xi0|qb 866:ln_xarr|x_r0c0|n_61  c=4.70423e-17
cg931 964:xxarr|xi0|qb 0  c=3.29575e-18
c930 964:xxarr|xi0|qb 936:xxarr|xi0|q  c=2.90803e-18
c929 964:xxarr|xi0|qb 937:xxarr|xi0|q  c=6.96305e-19
c928 964:xxarr|xi0|qb 315:ln_xarr|x_r0c0|n_62  c=2.05045e-18
c927 964:xxarr|xi0|qb 865:ln_xarr|x_r0c0|n_61  c=1.54693e-20
c926 964:xxarr|xi0|qb 866:ln_xarr|x_r0c0|n_61  c=2.55086e-19
cg925 949:xxarr|xi0|qb 0  c=4.70183e-18
c924 949:xxarr|xi0|qb 317:ln_xarr|x_r0c0|n_62  c=2.04324e-18
cg923 xxarr|xi0|mpd2|drn 0  c=3.00051e-17
c922 xxarr|xi0|mpd2|drn 315:ln_xarr|x_r0c0|n_62  c=1.04718e-17
c921 xxarr|xi0|mpd2|drn xxarr|xi0|mpg2|src  c=2.86429e-17
c920 xxarr|xi0|mpd2|drn xxarr|xi0|mpg1|src  c=1.77411e-19
cg919 xxarr|xi0|mpu2|drn 0  c=3.94752e-17
c918 xxarr|xi0|mpu2|drn 317:ln_xarr|x_r0c0|n_62  c=2.08119e-17
c917 xxarr|xi0|mpu2|drn 916:xxarr|xi0|q  c=1.77411e-19
cg916 944:xxarr|xi0|qb 0  c=2.20043e-18
c915 944:xxarr|xi0|qb 302:ln_xarr|x_r0c0|n_64  c=3.0147e-19
cg914 940:xxarr|xi0|q 0  c=7.45148e-17
c913 940:xxarr|xi0|q 859:wbl0  c=3.205e-17
c912 940:xxarr|xi0|q 317:ln_xarr|x_r0c0|n_62  c=8.12398e-19
c911 940:xxarr|xi0|q 876:rwl0  c=3.74997e-18
c910 940:xxarr|xi0|q 865:ln_xarr|x_r0c0|n_61  c=2.07097e-17
c909 940:xxarr|xi0|q 867:rwl0  c=7.83623e-17
c908 940:xxarr|xi0|q 866:ln_xarr|x_r0c0|n_61  c=1.03838e-17
c907 940:xxarr|xi0|q 864:ln_xarr|x_r0c0|n_61  c=1.95052e-17
cg906 939:xxarr|xi0|q 0  c=4.66803e-18
c905 939:xxarr|xi0|q 859:wbl0  c=6.29365e-20
c904 939:xxarr|xi0|q 317:ln_xarr|x_r0c0|n_62  c=1.352e-17
c903 939:xxarr|xi0|q 315:ln_xarr|x_r0c0|n_62  c=1.43359e-17
c902 939:xxarr|xi0|q 316:ln_xarr|x_r0c0|n_62  c=3.98465e-17
c901 939:xxarr|xi0|q 867:rwl0  c=1.2738e-17
c900 939:xxarr|xi0|q 641:wwl0  c=1.23346e-17
c899 939:xxarr|xi0|q 864:ln_xarr|x_r0c0|n_61  c=1.00959e-17
cg898 938:xxarr|xi0|q 0  c=1.96214e-17
c897 938:xxarr|xi0|q 643:wwl0  c=8.89255e-19
c896 938:xxarr|xi0|q 859:wbl0  c=6.51245e-18
c895 938:xxarr|xi0|q 901:rwl0  c=3.69549e-19
c894 938:xxarr|xi0|q 867:rwl0  c=5.28618e-17
c893 938:xxarr|xi0|q 641:wwl0  c=5.35251e-17
c892 937:xxarr|xi0|q 642:wwl0  c=1.90707e-20
c891 937:xxarr|xi0|q 857:wbl0  c=8.46451e-20
c890 937:xxarr|xi0|q 859:wbl0  c=9.27503e-18
c889 937:xxarr|xi0|q 317:ln_xarr|x_r0c0|n_62  c=1.73008e-19
c888 937:xxarr|xi0|q 315:ln_xarr|x_r0c0|n_62  c=1.73008e-19
c887 937:xxarr|xi0|q 316:ln_xarr|x_r0c0|n_62  c=7.08748e-19
c886 937:xxarr|xi0|q 876:rwl0  c=1.90707e-20
c885 937:xxarr|xi0|q 867:rwl0  c=7.72508e-18
c884 937:xxarr|xi0|q 641:wwl0  c=7.95323e-18
c883 937:xxarr|xi0|q 864:ln_xarr|x_r0c0|n_61  c=1.70402e-17
c882 937:xxarr|xi0|q 674:wwl0  c=1.72316e-19
c881 937:xxarr|xi0|q 668:wwl0  c=6.84189e-19
cg880 936:xxarr|xi0|q 0  c=3.13543e-17
c879 936:xxarr|xi0|q 642:wwl0  c=9.45407e-19
c878 936:xxarr|xi0|q 857:wbl0  c=4.19982e-19
c877 936:xxarr|xi0|q 847:wbl0  c=4.13639e-19
c876 936:xxarr|xi0|q 859:wbl0  c=1.63543e-17
c875 936:xxarr|xi0|q 315:ln_xarr|x_r0c0|n_62  c=8.56737e-19
c874 936:xxarr|xi0|q 851:wbl0  c=5.05435e-19
c873 936:xxarr|xi0|q 678:wwl0  c=1.78728e-18
c872 936:xxarr|xi0|q 641:wwl0  c=8.44976e-17
c871 936:xxarr|xi0|q 864:ln_xarr|x_r0c0|n_61  c=3.0621e-17
c870 936:xxarr|xi0|q 674:wwl0  c=2.94004e-19
c869 936:xxarr|xi0|q 668:wwl0  c=2.91179e-18
cg868 933:xxarr|xi0|q 0  c=3.11554e-18
c867 933:xxarr|xi0|q 317:ln_xarr|x_r0c0|n_62  c=5.54833e-20
c866 933:xxarr|xi0|q 316:ln_xarr|x_r0c0|n_62  c=1.18022e-18
c865 933:xxarr|xi0|q 864:ln_xarr|x_r0c0|n_61  c=2.05045e-18
cg864 xxarr|xi0|mpg1|src 0  c=3.13748e-17
c863 xxarr|xi0|mpg1|src xxwd0|xi1|mm1|drn  c=3.24526e-19
c862 xxarr|xi0|mpg1|src 836:wbl0  c=2.8718e-17
c861 xxarr|xi0|mpg1|src 864:ln_xarr|x_r0c0|n_61  c=1.04718e-17
cg860 919:xxarr|xi0|q 0  c=4.21895e-18
cg859 916:xxarr|xi0|q 0  c=3.42378e-17
c858 916:xxarr|xi0|q 865:ln_xarr|x_r0c0|n_61  c=1.42736e-17
cg857 915:ln_xarr|x_r0c1|n_61 0  c=1.72909e-17
c856 915:ln_xarr|x_r0c1|n_61 320:ln_xarr|x_r0c1|n_62  c=2.13518e-17
cg855 914:ln_xarr|x_r0c1|n_61 0  c=4.39806e-17
c854 914:ln_xarr|x_r0c1|n_61 320:ln_xarr|x_r0c1|n_62  c=1.38757e-17
cg853 913:ln_xarr|x_r0c1|n_61 0  c=4.28208e-17
c852 913:ln_xarr|x_r0c1|n_61 320:ln_xarr|x_r0c1|n_62  c=1.54774e-17
c851 913:ln_xarr|x_r0c1|n_61 318:ln_xarr|x_r0c1|n_62  c=2.328e-17
c850 913:ln_xarr|x_r0c1|n_61 319:ln_xarr|x_r0c1|n_62  c=1.59518e-17
cg849 912:rwl0 0  c=2.72724e-17
c848 912:rwl0 302:ln_xarr|x_r0c0|n_64  c=9.74023e-19
c847 912:rwl0 788:wbl1  c=3.95511e-19
c846 912:rwl0 427:rwl1  c=6.41191e-19
c845 912:rwl0 641:wwl0  c=4.27035e-18
c844 912:rwl0 303:ln_xarr|x_r0c0|n_64  c=1.19879e-17
cg843 911:rwl0 0  c=2.72077e-17
c842 911:rwl0 312:ln_xarr|x_r0c1|n_64  c=1.1961e-17
c841 911:rwl0 311:ln_xarr|x_r0c1|n_64  c=9.43857e-19
c840 911:rwl0 676:wwl0  c=4.27551e-18
c839 911:rwl0 425:rwl1  c=6.41191e-19
cg838 910:rwl0 0  c=1.10952e-17
c837 910:rwl0 397:rwl1  c=8.78515e-18
c836 910:rwl0 592:wwl1  c=4.32526e-19
c835 910:rwl0 423:rwl1  c=6.30001e-19
cg834 909:rwl0 0  c=1.95426e-18
c833 909:rwl0 643:wwl0  c=2.38498e-18
c832 909:rwl0 592:wwl1  c=4.2503e-19
cg831 908:rwl0 0  c=2.05389e-16
c830 908:rwl0 788:wbl1  c=9.93465e-17
c829 908:rwl0 676:wwl0  c=4.91162e-17
c828 908:rwl0 673:wwl0  c=5.13004e-18
cg827 907:rwl0 0  c=4.40036e-16
c826 907:rwl0 423:rwl1  c=2.65474e-19
c825 907:rwl0 643:wwl0  c=9.16617e-17
c824 907:rwl0 623:wwl1  c=2.86392e-19
c823 907:rwl0 613:wwl1  c=1.00177e-19
c822 907:rwl0 592:wwl1  c=5.22618e-19
c821 907:rwl0 622:wwl1  c=4.14357e-19
c820 907:rwl0 593:wwl1  c=8.5507e-17
c819 907:rwl0 594:wwl1  c=5.08216e-19
cg818 906:rwl0 0  c=1.32054e-18
c817 906:rwl0 643:wwl0  c=6.63068e-19
c816 906:rwl0 642:wwl0  c=5.96277e-18
cg815 905:rwl0 0  c=6.27005e-17
c814 905:rwl0 423:rwl1  c=8.66719e-17
c813 905:rwl0 422:rwl1  c=6.36812e-18
c812 905:rwl0 397:rwl1  c=1.23489e-16
c811 905:rwl0 643:wwl0  c=1.84997e-17
c810 905:rwl0 415:rwl1  c=1.19172e-17
c809 905:rwl0 394:rwl1  c=1.87279e-17
c808 905:rwl0 592:wwl1  c=1.64587e-18
c807 905:rwl0 593:wwl1  c=1.84823e-16
cg806 901:rwl0 0  c=2.09285e-18
c805 901:rwl0 642:wwl0  c=1.1406e-17
c804 901:rwl0 643:wwl0  c=2.45832e-18
c803 898:rwl0 423:rwl1  c=1.00525e-19
c802 898:rwl0 593:wwl1  c=6.36812e-18
c801 898:rwl0 592:wwl1  c=1.43943e-18
c800 898:rwl0 397:rwl1  c=1.50302e-17
c799 898:rwl0 643:wwl0  c=5.84283e-19
cg798 880:rwl0 0  c=8.5735e-17
c797 880:rwl0 418:rwl1  c=2.95646e-18
c796 880:rwl0 642:wwl0  c=1.03647e-18
c795 880:rwl0 397:rwl1  c=8.43209e-17
c794 880:rwl0 643:wwl0  c=3.02148e-17
c793 880:rwl0 613:wwl1  c=1.58516e-17
c792 880:rwl0 426:rwl1  c=1.94227e-18
c791 880:rwl0 420:rwl1  c=2.17949e-18
c790 880:rwl0 396:rwl1  c=5.00009e-18
c789 880:rwl0 592:wwl1  c=1.00544e-16
c788 880:rwl0 622:wwl1  c=1.49958e-17
c787 880:rwl0 593:wwl1  c=1.14383e-16
cg786 878:rwl0 0  c=3.66276e-19
c785 878:rwl0 423:rwl1  c=4.16323e-19
c784 878:rwl0 643:wwl0  c=2.06431e-18
c783 878:rwl0 593:wwl1  c=1.87279e-17
c782 878:rwl0 592:wwl1  c=4.6094e-19
cg781 876:rwl0 0  c=2.92045e-16
c780 876:rwl0 418:rwl1  c=4.89611e-19
c779 876:rwl0 642:wwl0  c=5.23504e-17
c778 876:rwl0 643:wwl0  c=7.01317e-18
c777 876:rwl0 859:wbl0  c=1.12503e-17
c776 876:rwl0 420:rwl1  c=2.49764e-18
c775 876:rwl0 396:rwl1  c=1.8578e-18
c774 876:rwl0 592:wwl1  c=2.609e-19
c773 876:rwl0 674:wwl0  c=2.31159e-18
cg772 875:rwl0 0  c=6.44744e-18
c771 875:rwl0 303:ln_xarr|x_r0c0|n_64  c=2.07945e-18
c770 875:rwl0 388:rwl1  c=5.72095e-25
cg769 874:rwl0 0  c=3.32907e-18
c768 874:rwl0 387:rwl1  c=2.86048e-25
cg767 xxdec|xi3|mm1|drn 0  c=5.69947e-17
cg766 xxdec|xi3|mm0|drn 0  c=2.05289e-17
cg765 867:rwl0 0  c=1.80802e-16
c764 867:rwl0 788:wbl1  c=9.33902e-18
c763 867:rwl0 859:wbl0  c=9.78832e-17
c762 867:rwl0 673:wwl0  c=2.81494e-19
c761 867:rwl0 641:wwl0  c=4.14412e-17
c760 867:rwl0 674:wwl0  c=2.97853e-18
cg759 866:ln_xarr|x_r0c0|n_61 0  c=1.66209e-17
c758 866:ln_xarr|x_r0c0|n_61 317:ln_xarr|x_r0c0|n_62  c=2.13518e-17
cg757 865:ln_xarr|x_r0c0|n_61 0  c=4.08288e-17
c756 865:ln_xarr|x_r0c0|n_61 317:ln_xarr|x_r0c0|n_62  c=1.38757e-17
cg755 864:ln_xarr|x_r0c0|n_61 0  c=3.85185e-17
c754 864:ln_xarr|x_r0c0|n_61 317:ln_xarr|x_r0c0|n_62  c=1.54774e-17
c753 864:ln_xarr|x_r0c0|n_61 315:ln_xarr|x_r0c0|n_62  c=2.328e-17
c752 864:ln_xarr|x_r0c0|n_61 316:ln_xarr|x_r0c0|n_62  c=1.59518e-17
cg751 863:xxarr|xi0|net5 0  c=4.64662e-17
c750 863:xxarr|xi0|net5 302:ln_xarr|x_r0c0|n_64  c=2.99821e-19
c749 863:xxarr|xi0|net5 676:wwl0  c=1.72923e-18
c748 863:xxarr|xi0|net5 677:wwl0  c=9.15168e-19
c747 863:xxarr|xi0|net5 573:rbl0  c=1.46307e-17
c746 863:xxarr|xi0|net5 641:wwl0  c=3.21924e-17
c745 863:xxarr|xi0|net5 303:ln_xarr|x_r0c0|n_64  c=1.63523e-17
cg744 xxarr|xi0|mra1|drn 0  c=3.22625e-17
c743 xxarr|xi0|mra1|drn 303:ln_xarr|x_r0c0|n_64  c=1.04514e-17
c742 xxarr|xi0|mra1|drn 302:ln_xarr|x_r0c0|n_64  c=3.72463e-19
c741 xxarr|xi0|mra1|drn xxarr|xi0|mra2|drn  c=2.8718e-17
cg740 860:wbl0 0  c=1.74425e-17
c739 860:wbl0 xxwd0|xi1|mm1|gate  c=1.22275e-19
c738 860:wbl0 819:wblb0  c=1.37672e-19
c737 860:wbl0 833:wblb0  c=2.56117e-19
cg736 859:wbl0 0  c=4.27411e-16
c735 859:wbl0 642:wwl0  c=6.46092e-18
c734 859:wbl0 396:rwl1  c=1.21772e-17
c733 859:wbl0 591:wwl1  c=8.67177e-17
c732 859:wbl0 626:wwl1  c=2.37076e-17
c731 859:wbl0 392:rwl1  c=9.64596e-17
c730 859:wbl0 592:wwl1  c=7.10298e-18
c729 859:wbl0 678:wwl0  c=3.79197e-17
c728 859:wbl0 621:wwl1  c=2.33209e-17
c727 859:wbl0 641:wwl0  c=8.83077e-17
c726 859:wbl0 674:wwl0  c=2.33209e-17
c725 859:wbl0 589:wwl1  c=3.55992e-18
c724 859:wbl0 668:wwl0  c=3.96607e-18
cg723 858:wbl0 0  c=2.59804e-17
c722 858:wbl0 816:wblb0  c=4.44355e-18
c721 858:wbl0 824:wblb0  c=2.04381e-18
c720 858:wbl0 821:wblb0  c=1.42255e-19
c719 858:wbl0 806:wblb0  c=9.48369e-20
c718 858:wbl0 832:wblb0  c=1.56592e-19
c717 858:wbl0 641:wwl0  c=4.1973e-19
c716 858:wbl0 831:wblb0  c=5.94844e-19
c715 858:wbl0 826:wblb0  c=1.08306e-18
c714 858:wbl0 815:wblb0  c=1.55166e-18
cg713 857:wbl0 0  c=2.04523e-17
c712 857:wbl0 816:wblb0  c=9.95706e-19
c711 857:wbl0 824:wblb0  c=1.80866e-18
c710 857:wbl0 819:wblb0  c=2.39549e-19
c709 857:wbl0 833:wblb0  c=1.86985e-19
c708 857:wbl0 828:wblb0  c=2.50562e-19
c707 857:wbl0 xxwd0|xi1|mm1|gate  c=2.11393e-19
c706 857:wbl0 832:wblb0  c=6.31523e-19
c705 857:wbl0 831:wblb0  c=5.38975e-19
c704 857:wbl0 641:wwl0  c=2.91889e-19
c703 857:wbl0 826:wblb0  c=2.72683e-19
c702 857:wbl0 815:wblb0  c=4.09025e-19
cg701 856:wbl0 0  c=4.52088e-16
c700 856:wbl0 816:wblb0  c=5.3814e-19
c699 856:wbl0 824:wblb0  c=4.77397e-19
c698 856:wbl0 822:wblb0  c=1.69357e-20
c697 856:wbl0 819:wblb0  c=1.22557e-16
c696 856:wbl0 823:wblb0  c=2.45928e-23
c695 856:wbl0 833:wblb0  c=1.24871e-17
c694 856:wbl0 827:wblb0  c=2.58653e-18
c693 856:wbl0 818:wblb0  c=2.58909e-18
c692 856:wbl0 828:wblb0  c=1.01981e-16
c691 856:wbl0 829:wblb0  c=5.56938e-21
c690 856:wbl0 820:wblb0  c=5.7756e-21
c689 856:wbl0 xxwd0|xi1|mm0|gate  c=6.8332e-18
c688 856:wbl0 xxwd0|xi1|mm1|gate  c=1.77675e-17
c687 856:wbl0 831:wblb0  c=2.51573e-19
cg686 855:wbl0 0  c=1.53442e-17
c685 855:wbl0 824:wblb0  c=4.33383e-19
c684 855:wbl0 816:wblb0  c=1.22838e-18
c683 855:wbl0 815:wblb0  c=4.75581e-19
cg682 854:wbl0 0  c=9.4406e-18
c681 854:wbl0 819:wblb0  c=3.24606e-19
c680 854:wbl0 833:wblb0  c=1.28553e-19
c679 854:wbl0 827:wblb0  c=4.81208e-19
c678 854:wbl0 xxwd0|xi1|mm1|gate  c=3.04407e-19
c677 854:wbl0 678:wwl0  c=8.99752e-19
c676 854:wbl0 641:wwl0  c=1.59583e-19
c675 854:wbl0 668:wwl0  c=3.85905e-19
cg674 853:wbl0 0  c=2.45201e-17
c673 853:wbl0 678:wwl0  c=1.68836e-19
c672 853:wbl0 641:wwl0  c=1.07174e-18
c671 853:wbl0 643:wwl0  c=2.58833e-19
cg670 852:wbl0 0  c=2.44837e-17
c669 852:wbl0 672:wwl0  c=2.78085e-19
c668 852:wbl0 643:wwl0  c=7.32664e-20
cg667 851:wbl0 0  c=2.33338e-17
c666 851:wbl0 678:wwl0  c=1.45969e-19
c665 851:wbl0 833:wblb0  c=1.25669e-19
c664 851:wbl0 672:wwl0  c=4.05314e-19
c663 851:wbl0 641:wwl0  c=4.48228e-19
c662 851:wbl0 643:wwl0  c=8.68938e-19
cg661 847:wbl0 0  c=2.98675e-17
c660 847:wbl0 816:wblb0  c=8.5815e-19
c659 847:wbl0 824:wblb0  c=2.88922e-19
c658 847:wbl0 641:wwl0  c=1.02045e-18
c657 847:wbl0 826:wblb0  c=3.17054e-19
cg656 xxwd0|xi1|mm0|drn 0  c=1.66781e-17
c655 xxwd0|xi1|mm0|drn 819:wblb0  c=4.81831e-17
cg654 xxwd0|xi1|mm1|drn 0  c=4.67209e-17
c653 xxwd0|xi1|mm1|drn 819:wblb0  c=1.35638e-16
cg652 836:wbl0 0  c=2.28444e-18
c651 836:wbl0 819:wblb0  c=1.04043e-19
cg650 834:wbl0 0  c=1.49029e-18
cg649 833:wblb0 0  c=1.14483e-17
c648 833:wblb0 375:din0  c=7.70833e-21
c647 833:wblb0 381:din0  c=2.74034e-23
cg646 832:wblb0 0  c=7.58417e-16
c645 832:wblb0 667:wwl0  c=3.83353e-18
c644 832:wblb0 641:wwl0  c=1.07432e-16
c643 832:wblb0 676:wwl0  c=3.16022e-19
c642 832:wblb0 307:ln_xarr|x_r1c0|n_64  c=2.1437e-17
c641 832:wblb0 303:ln_xarr|x_r0c0|n_64  c=2.06055e-17
c640 832:wblb0 306:ln_xarr|x_r1c0|n_64  c=4.16054e-18
c639 832:wblb0 677:wwl0  c=1.01506e-23
c638 832:wblb0 302:ln_xarr|x_r0c0|n_64  c=4.16054e-18
c637 832:wblb0 673:wwl0  c=7.56539e-20
cg636 831:wblb0 0  c=1.5961e-17
c635 831:wblb0 xxwd0|xi0|mm1|gate  c=1.3104e-19
c634 831:wblb0 375:din0  c=1.36355e-19
cg633 830:wblb0 0  c=3.35959e-17
c632 830:wblb0 641:wwl0  c=8.11085e-19
cg631 829:wblb0 0  c=1.18746e-17
c630 829:wblb0 381:din0  c=2.51615e-18
cg629 828:wblb0 0  c=6.46365e-17
c628 828:wblb0 381:din0  c=8.77621e-17
c627 828:wblb0 377:din0  c=4.10778e-19
cg626 827:wblb0 0  c=1.15209e-17
cg625 826:wblb0 0  c=2.35005e-17
c624 826:wblb0 641:wwl0  c=1.12303e-18
cg623 825:wblb0 0  c=2.857e-17
c622 825:wblb0 302:ln_xarr|x_r0c0|n_64  c=3.64907e-20
c621 825:wblb0 375:din0  c=2.76157e-19
c620 825:wblb0 xxwd0|xi0|mm1|gate  c=2.69503e-19
c619 825:wblb0 303:ln_xarr|x_r0c0|n_64  c=1.00637e-18
cg618 824:wblb0 0  c=6.0034e-18
c617 824:wblb0 375:din0  c=4.78851e-19
c616 824:wblb0 xxwd0|xi0|mm1|gate  c=4.728e-19
c615 824:wblb0 641:wwl0  c=1.71482e-19
cg614 823:wblb0 0  c=6.65653e-18
c613 823:wblb0 375:din0  c=2.25638e-17
c612 823:wblb0 xxwd0|xi0|mm0|gate  c=5.45475e-19
c611 823:wblb0 381:din0  c=8.96331e-18
cg610 822:wblb0 0  c=2.95617e-17
c609 822:wblb0 375:din0  c=2.56443e-17
c608 822:wblb0 xxwd0|xi0|mm0|gate  c=4.01963e-18
c607 822:wblb0 381:din0  c=1.87542e-17
cg606 821:wblb0 0  c=2.28852e-17
cg605 820:wblb0 0  c=1.05344e-17
c604 820:wblb0 381:din0  c=2.57031e-18
cg603 819:wblb0 0  c=4.15348e-16
c602 819:wblb0 375:din0  c=6.94849e-18
c601 819:wblb0 381:din0  c=8.02778e-19
cg600 818:wblb0 0  c=1.4877e-17
c599 818:wblb0 381:din0  c=6.56343e-21
cg598 816:wblb0 0  c=2.22257e-17
c597 816:wblb0 641:wwl0  c=2.90582e-19
cg596 815:wblb0 0  c=2.31856e-17
cg595 806:wblb0 0  c=3.11058e-17
c594 806:wblb0 641:wwl0  c=1.02045e-18
cg593 xxwd0|xi0|mm0|drn 0  c=1.39691e-17
c592 xxwd0|xi0|mm0|drn 303:ln_xarr|x_r0c0|n_64  c=3.79718e-19
c591 xxwd0|xi0|mm0|drn 375:din0  c=4.73018e-17
cg590 xxarr|xi0|mpg2|src 0  c=2.63281e-17
c589 xxarr|xi0|mpg2|src 303:ln_xarr|x_r0c0|n_64  c=5.97602e-19
c588 xxarr|xi0|mpg2|src 375:din0  c=1.04351e-19
cg587 xxarr|xi2|mpg2|src 0  c=2.8586e-17
c586 xxarr|xi2|mpg2|src 307:ln_xarr|x_r1c0|n_64  c=5.97602e-19
cg585 xxwd0|xi0|mm1|drn 0  c=3.96257e-17
c584 xxwd0|xi0|mm1|drn 303:ln_xarr|x_r0c0|n_64  c=1.1454e-18
c583 xxwd0|xi0|mm1|drn 375:din0  c=1.38059e-16
c582 xxwd0|xi1|mm0|gate 375:din0  c=5.43056e-19
cg581 xxwd0|xi1|mm1|gate 0  c=1.32369e-18
c580 xxwd0|xi1|mm1|gate 375:din0  c=1.56129e-18
cg579 789:wbl1 0  c=1.70786e-17
c578 789:wbl1 xxwd1|xi1|mm1|gate  c=1.22275e-19
c577 789:wbl1 751:wblb1  c=1.37672e-19
c576 789:wbl1 762:wblb1  c=2.56117e-19
cg575 788:wbl1 0  c=4.42163e-16
c574 788:wbl1 427:rwl1  c=3.95511e-19
c573 788:wbl1 591:wwl1  c=6.85609e-19
c572 788:wbl1 392:rwl1  c=8.51454e-18
c571 788:wbl1 641:wwl0  c=7.29358e-19
c570 788:wbl1 624:wwl1  c=9.23048e-17
c569 788:wbl1 424:rwl1  c=9.75859e-17
c568 788:wbl1 676:wwl0  c=9.39298e-17
c567 788:wbl1 625:wwl1  c=2.36507e-17
c566 788:wbl1 677:wwl0  c=3.76949e-17
c565 788:wbl1 620:wwl1  c=2.34247e-17
c564 788:wbl1 673:wwl0  c=2.32471e-17
c563 788:wbl1 666:wwl0  c=9.49829e-19
cg562 787:wbl1 0  c=2.62755e-17
c561 787:wbl1 676:wwl0  c=4.1973e-19
c560 787:wbl1 757:wblb1  c=1.08306e-18
c559 787:wbl1 747:wblb1  c=1.55166e-18
c558 787:wbl1 748:wblb1  c=4.44355e-18
c557 787:wbl1 761:wblb1  c=1.56592e-19
c556 787:wbl1 760:wblb1  c=5.94844e-19
c555 787:wbl1 755:wblb1  c=2.04381e-18
c554 787:wbl1 735:wblb1  c=9.48369e-20
c553 787:wbl1 740:wblb1  c=1.42255e-19
cg552 786:wbl1 0  c=2.49769e-17
c551 786:wbl1 677:wwl0  c=1.68836e-19
c550 786:wbl1 676:wwl0  c=1.07174e-18
cg549 785:wbl1 0  c=2.07563e-17
c548 785:wbl1 762:wblb1  c=1.86985e-19
c547 785:wbl1 751:wblb1  c=2.39549e-19
c546 785:wbl1 676:wwl0  c=2.91889e-19
c545 785:wbl1 757:wblb1  c=2.72683e-19
c544 785:wbl1 747:wblb1  c=4.09025e-19
c543 785:wbl1 748:wblb1  c=9.95706e-19
c542 785:wbl1 761:wblb1  c=6.31523e-19
c541 785:wbl1 760:wblb1  c=5.38975e-19
c540 785:wbl1 755:wblb1  c=1.80866e-18
c539 785:wbl1 xxwd1|xi1|mm1|gate  c=2.11393e-19
c538 785:wbl1 759:wblb1  c=2.50562e-19
cg537 784:wbl1 0  c=4.55502e-16
c536 784:wbl1 762:wblb1  c=1.24871e-17
c535 784:wbl1 751:wblb1  c=1.22547e-16
c534 784:wbl1 747:wblb1  c=4.43076e-20
c533 784:wbl1 748:wblb1  c=6.20008e-19
c532 784:wbl1 760:wblb1  c=2.51573e-19
c531 784:wbl1 755:wblb1  c=4.77397e-19
c530 784:wbl1 xxwd1|xi1|mm0|gate  c=6.8332e-18
c529 784:wbl1 752:wblb1  c=1.69357e-20
c528 784:wbl1 xxwd1|xi1|mm1|gate  c=1.77675e-17
c527 784:wbl1 758:wblb1  c=2.58697e-18
c526 784:wbl1 750:wblb1  c=2.58977e-18
c525 784:wbl1 754:wblb1  c=2.45928e-23
c524 784:wbl1 759:wblb1  c=1.01758e-16
c523 784:wbl1 756:wblb1  c=7.10155e-21
c522 784:wbl1 744:wblb1  c=5.7756e-21
cg521 783:wbl1 0  c=9.02882e-18
c520 783:wbl1 762:wblb1  c=1.28553e-19
c519 783:wbl1 751:wblb1  c=3.24606e-19
c518 783:wbl1 676:wwl0  c=1.59583e-19
c517 783:wbl1 677:wwl0  c=8.99752e-19
c516 783:wbl1 xxwd1|xi1|mm1|gate  c=3.04407e-19
c515 783:wbl1 758:wblb1  c=4.81208e-19
cg514 782:wbl1 0  c=1.55525e-17
c513 782:wbl1 755:wblb1  c=4.33383e-19
c512 782:wbl1 748:wblb1  c=1.22838e-18
c511 782:wbl1 747:wblb1  c=4.75581e-19
cg510 781:wbl1 0  c=2.32629e-17
c509 781:wbl1 762:wblb1  c=1.25669e-19
c508 781:wbl1 676:wwl0  c=4.48228e-19
c507 781:wbl1 677:wwl0  c=1.45969e-19
cg506 780:wbl1 0  c=2.50554e-17
cg505 776:wbl1 0  c=3.00433e-17
c504 776:wbl1 676:wwl0  c=1.02045e-18
c503 776:wbl1 757:wblb1  c=3.17054e-19
c502 776:wbl1 748:wblb1  c=8.5815e-19
c501 776:wbl1 755:wblb1  c=2.88922e-19
cg500 xxwd1|xi1|mm0|drn 0  c=1.66781e-17
c499 xxwd1|xi1|mm0|drn 751:wblb1  c=4.81831e-17
cg498 xxwd1|xi1|mm1|drn 0  c=4.67209e-17
c497 xxwd1|xi1|mm1|drn 751:wblb1  c=1.35638e-16
cg496 765:wbl1 0  c=8.64832e-18
c495 765:wbl1 751:wblb1  c=1.04043e-19
cg494 763:wbl1 0  c=7.81382e-18
cg493 762:wblb1 0  c=1.30184e-17
c492 762:wblb1 364:din1  c=7.70833e-21
c491 762:wblb1 369:din1  c=2.74034e-23
cg490 761:wblb1 0  c=8.26813e-16
c489 761:wblb1 676:wwl0  c=1.08041e-16
c488 761:wblb1 314:ln_xarr|x_r1c1|n_64  c=2.12249e-17
c487 761:wblb1 312:ln_xarr|x_r0c1|n_64  c=2.07705e-17
c486 761:wblb1 313:ln_xarr|x_r1c1|n_64  c=4.16054e-18
c485 761:wblb1 665:wwl0  c=3.83353e-18
c484 761:wblb1 311:ln_xarr|x_r0c1|n_64  c=4.16054e-18
cg483 760:wblb1 0  c=1.83209e-17
c482 760:wblb1 xxwd1|xi0|mm1|gate  c=1.3104e-19
c481 760:wblb1 364:din1  c=1.36355e-19
cg480 759:wblb1 0  c=7.03475e-17
c479 759:wblb1 369:din1  c=8.77593e-17
c478 759:wblb1 365:din1  c=4.10778e-19
cg477 758:wblb1 0  c=1.37095e-17
cg476 757:wblb1 0  c=2.46953e-17
c475 757:wblb1 676:wwl0  c=1.12303e-18
cg474 756:wblb1 0  c=1.38681e-17
c473 756:wblb1 369:din1  c=2.51613e-18
cg472 755:wblb1 0  c=9.70195e-18
c471 755:wblb1 364:din1  c=4.78851e-19
c470 755:wblb1 676:wwl0  c=1.71482e-19
c469 755:wblb1 xxwd1|xi0|mm1|gate  c=4.728e-19
cg468 754:wblb1 0  c=5.3591e-18
c467 754:wblb1 369:din1  c=9.03148e-18
c466 754:wblb1 xxwd1|xi0|mm0|gate  c=5.45475e-19
c465 754:wblb1 364:din1  c=2.17544e-17
cg464 753:wblb1 0  c=3.73394e-17
c463 753:wblb1 312:ln_xarr|x_r0c1|n_64  c=1.00637e-18
c462 753:wblb1 xxwd1|xi0|mm1|gate  c=2.69503e-19
c461 753:wblb1 311:ln_xarr|x_r0c1|n_64  c=3.64907e-20
c460 753:wblb1 364:din1  c=2.76157e-19
cg459 752:wblb1 0  c=3.24585e-17
c458 752:wblb1 369:din1  c=1.88565e-17
c457 752:wblb1 xxwd1|xi0|mm0|gate  c=4.00809e-18
c456 752:wblb1 364:din1  c=2.56425e-17
cg455 751:wblb1 0  c=4.25538e-16
c454 751:wblb1 364:din1  c=6.94849e-18
c453 751:wblb1 369:din1  c=8.02778e-19
cg452 750:wblb1 0  c=1.616e-17
c451 750:wblb1 369:din1  c=6.56343e-21
cg450 748:wblb1 0  c=2.46813e-17
c449 748:wblb1 676:wwl0  c=2.90582e-19
cg448 747:wblb1 0  c=2.52287e-17
cg447 744:wblb1 0  c=1.14099e-17
c446 744:wblb1 369:din1  c=2.57023e-18
cg445 740:wblb1 0  c=2.53716e-17
cg444 738:wblb1 0  c=3.26358e-17
c443 738:wblb1 676:wwl0  c=8.11085e-19
cg442 735:wblb1 0  c=3.41835e-17
c441 735:wblb1 676:wwl0  c=1.02045e-18
cg440 xxwd1|xi0|mm0|drn 0  c=8.53772e-18
c439 xxwd1|xi0|mm0|drn 312:ln_xarr|x_r0c1|n_64  c=3.79718e-19
c438 xxwd1|xi0|mm0|drn 364:din1  c=4.72771e-17
cg437 xxarr|xi1|mpg2|src 0  c=2.63281e-17
c436 xxarr|xi1|mpg2|src 312:ln_xarr|x_r0c1|n_64  c=5.97602e-19
c435 xxarr|xi1|mpg2|src 364:din1  c=1.04351e-19
cg434 xxarr|xi3|mpg2|src 0  c=2.58136e-17
c433 xxarr|xi3|mpg2|src 314:ln_xarr|x_r1c1|n_64  c=5.97602e-19
cg432 xxwd1|xi0|mm1|drn 0  c=2.45464e-17
c431 xxwd1|xi0|mm1|drn 312:ln_xarr|x_r0c1|n_64  c=1.1454e-18
c430 xxwd1|xi0|mm1|drn 364:din1  c=1.12479e-16
c429 xxwd1|xi1|mm0|gate 364:din1  c=5.43056e-19
cg428 xxwd1|xi1|mm1|gate 0  c=1.32369e-18
c427 xxwd1|xi1|mm1|gate 364:din1  c=1.56129e-18
cg426 718:rbl1 0  c=3.90069e-16
c425 718:rbl1 542:preb  c=6.06725e-17
c424 718:rbl1 544:preb  c=1.36506e-19
c423 718:rbl1 543:preb  c=2.26923e-18
c422 718:rbl1 537:preb  c=1.60155e-20
c421 718:rbl1 539:preb  c=2.04519e-18
c420 718:rbl1 535:preb  c=2.04573e-18
c419 718:rbl1 534:preb  c=9.58979e-18
c418 718:rbl1 540:preb  c=7.8949e-17
c417 718:rbl1 305:ln_xrs1|n_38  c=6.41764e-17
c416 718:rbl1 538:preb  c=3.71149e-19
c415 718:rbl1 541:preb  c=4.82875e-18
c414 718:rbl1 530:preb  c=7.38899e-19
c413 718:rbl1 533:preb  c=1.18285e-17
c412 718:rbl1 527:preb  c=1.05517e-17
cg411 717:rbl1 0  c=3.82307e-16
cg410 716:rbl1 0  c=8.8401e-16
c409 716:rbl1 313:ln_xarr|x_r1c1|n_64  c=3.49185e-18
c408 716:rbl1 424:rwl1  c=9.84418e-17
c407 716:rbl1 425:rwl1  c=2.70634e-17
c406 716:rbl1 387:rwl1  c=3.06849e-18
c405 716:rbl1 314:ln_xarr|x_r1c1|n_64  c=4.10598e-18
cg404 715:rbl1 0  c=7.74007e-18
c403 715:rbl1 313:ln_xarr|x_r1c1|n_64  c=6.38603e-20
c402 715:rbl1 387:rwl1  c=5.70664e-20
c401 715:rbl1 314:ln_xarr|x_r1c1|n_64  c=1.32909e-18
cg400 714:rbl1 0  c=4.06465e-16
c399 714:rbl1 313:ln_xarr|x_r1c1|n_64  c=6.50573e-19
c398 714:rbl1 314:ln_xarr|x_r1c1|n_64  c=3.66181e-19
cg397 713:rbl1 0  c=4.73533e-17
cg396 709:rbl1 0  c=2.12644e-17
cg395 708:rbl1 0  c=1.50411e-17
cg394 704:rbl1 0  c=3.74939e-17
cg393 703:rbl1 0  c=1.75648e-17
cg392 702:rbl1 0  c=6.83257e-18
cg391 701:rbl1 0  c=3.47104e-17
c390 701:rbl1 387:rwl1  c=2.26899e-19
cg389 xxrs1|xis1|mm1|gate 0  c=2.4505e-17
cg388 688:rbl1 0  c=3.67346e-16
c387 688:rbl1 541:preb  c=3.88342e-19
c386 688:rbl1 533:preb  c=3.99852e-20
cg385 xxrs1|mmpre|drn 0  c=5.92632e-17
c384 xxrs1|mmpre|drn 305:ln_xrs1|n_38  c=8.26138e-17
cg383 xxarr|xi1|mra2|drn 0  c=1.77411e-19
cg382 xxarr|xi3|mra2|drn 0  c=4.63177e-19
cg381 xxrs1|xis1|mm0|gate 0  c=3.67825e-18
c380 xxrs1|xis1|mm0|gate 314:ln_xarr|x_r1c1|n_64  c=2.11406e-21
c379 xxrs1|xis1|mm0|gate 313:ln_xarr|x_r1c1|n_64  c=2.43828e-22
cg378 678:wwl0 0  c=1.13846e-16
c377 678:wwl0 621:wwl1  c=2.71981e-21
cg376 677:wwl0 0  c=1.13213e-16
c375 677:wwl0 620:wwl1  c=2.71981e-21
cg374 676:wwl0 0  c=1.73687e-16
cg373 675:wwl0 0  c=4.31338e-16
c372 675:wwl0 623:wwl1  c=1.89395e-19
cg371 674:wwl0 0  c=8.98886e-18
c370 674:wwl0 626:wwl1  c=2.71981e-21
c369 674:wwl0 621:wwl1  c=3.02531e-18
cg368 673:wwl0 0  c=1.24465e-17
c367 673:wwl0 625:wwl1  c=2.71981e-21
c366 673:wwl0 620:wwl1  c=3.02531e-18
cg365 672:wwl0 0  c=6.23219e-18
cg364 668:wwl0 0  c=2.17976e-18
c363 668:wwl0 589:wwl1  c=4.59941e-20
cg362 667:wwl0 0  c=7.07289e-19
c361 667:wwl0 616:wwl1  c=7.7951e-22
cg360 666:wwl0 0  c=2.22543e-18
c359 666:wwl0 586:wwl1  c=7.7951e-22
cg358 665:wwl0 0  c=7.07289e-19
c357 665:wwl0 615:wwl1  c=7.7951e-22
cg356 663:wwl0 0  c=1.2535e-17
c355 663:wwl0 623:wwl1  c=1.00067e-19
cg354 644:wwl0 0  c=2.61435e-17
c353 644:wwl0 623:wwl1  c=4.44689e-19
cg352 643:wwl0 0  c=8.62062e-16
c351 643:wwl0 623:wwl1  c=8.27453e-17
c350 643:wwl0 613:wwl1  c=6.36812e-18
c349 643:wwl0 592:wwl1  c=2.21251e-18
c348 643:wwl0 593:wwl1  c=3.51936e-16
c347 643:wwl0 594:wwl1  c=1.87922e-17
cg346 642:wwl0 0  c=3.22129e-16
c345 642:wwl0 623:wwl1  c=6.91285e-19
c344 642:wwl0 613:wwl1  c=2.08408e-18
c343 642:wwl0 622:wwl1  c=5.8593e-19
c342 642:wwl0 593:wwl1  c=2.28555e-18
c341 642:wwl0 594:wwl1  c=6.29842e-19
cg340 641:wwl0 0  c=1.59797e-16
cg339 xxdec|xi1|mm1|drn 0  c=5.69947e-17
cg338 xxdec|xi1|mm0|drn 0  c=2.05289e-17
cg337 626:wwl1 0  c=1.17469e-16
c336 626:wwl1 397:rwl1  c=3.48327e-19
c335 626:wwl1 572:rbl0  c=3.08435e-18
cg334 625:wwl1 0  c=1.08825e-16
c333 625:wwl1 573:rbl0  c=1.72978e-17
cg332 624:wwl1 0  c=2.82701e-16
c331 624:wwl1 424:rwl1  c=4.92859e-17
c330 624:wwl1 425:rwl1  c=4.27551e-18
c329 624:wwl1 573:rbl0  c=8.45821e-18
cg328 623:wwl1 0  c=4.4097e-16
cg327 622:wwl1 0  c=5.46409e-18
cg326 621:wwl1 0  c=8.77953e-18
c325 621:wwl1 397:rwl1  c=4.33147e-20
c324 621:wwl1 572:rbl0  c=5.89295e-20
c323 621:wwl1 396:rwl1  c=2.29296e-18
c322 621:wwl1 392:rwl1  c=3.10127e-18
cg321 620:wwl1 0  c=4.58571e-18
c320 620:wwl1 424:rwl1  c=5.25279e-18
c319 620:wwl1 573:rbl0  c=7.93837e-18
c318 620:wwl1 392:rwl1  c=2.81494e-19
cg317 616:wwl1 0  c=3.60379e-18
cg316 615:wwl1 0  c=3.66275e-18
cg315 613:wwl1 0  c=3.07409e-19
cg314 594:wwl1 0  c=2.31433e-18
cg313 593:wwl1 0  c=9.38152e-17
c312 593:wwl1 423:rwl1  c=9.56368e-17
c311 593:wwl1 418:rwl1  c=1.64588e-19
c310 593:wwl1 422:rwl1  c=5.84283e-19
c309 593:wwl1 397:rwl1  c=2.34448e-17
c308 593:wwl1 568:rbl0  c=4.60226e-20
c307 593:wwl1 566:rbl0  c=6.06353e-19
c306 593:wwl1 572:rbl0  c=1.64685e-18
c305 593:wwl1 415:rwl1  c=1.63978e-18
c304 593:wwl1 426:rwl1  c=1.76377e-18
c303 593:wwl1 420:rwl1  c=1.76377e-18
c302 593:wwl1 394:rwl1  c=2.06431e-18
c301 593:wwl1 396:rwl1  c=5.57045e-18
cg300 592:wwl1 0  c=1.50516e-16
c299 592:wwl1 423:rwl1  c=5.51648e-21
c298 592:wwl1 422:rwl1  c=2.27965e-20
c297 592:wwl1 397:rwl1  c=1.11134e-16
c296 592:wwl1 566:rbl0  c=4.65403e-18
c295 592:wwl1 572:rbl0  c=3.58753e-18
c294 592:wwl1 426:rwl1  c=7.14571e-18
c293 592:wwl1 569:rbl0  c=1.63598e-18
c292 592:wwl1 396:rwl1  c=4.70188e-17
cg291 591:wwl1 0  c=1.5526e-16
c290 591:wwl1 397:rwl1  c=3.12086e-18
c289 591:wwl1 572:rbl0  c=6.00455e-18
c288 591:wwl1 573:rbl0  c=1.02724e-16
c287 591:wwl1 571:rbl0  c=1.4597e-18
c286 591:wwl1 392:rwl1  c=4.16109e-17
c285 591:wwl1 427:rwl1  c=4.27035e-18
cg284 xxdec|xi2|mm1|drn 0  c=5.69947e-17
cg283 xxdec|xi2|mm0|drn 0  c=2.05289e-17
cg282 589:wwl1 0  c=2.35606e-18
cg281 586:wwl1 0  c=2.29751e-18
cg280 574:rbl0 0  c=3.8205e-16
c279 574:rbl0 397:rwl1  c=4.3691e-18
cg278 573:rbl0 0  c=7.68249e-16
c277 573:rbl0 427:rwl1  c=2.70634e-17
c276 573:rbl0 392:rwl1  c=8.93167e-17
c275 573:rbl0 424:rwl1  c=9.30799e-18
c274 573:rbl0 388:rwl1  c=4.02217e-18
c273 573:rbl0 541:preb  c=5.08346e-24
cg272 572:rbl0 0  c=4.32485e-16
c271 572:rbl0 397:rwl1  c=3.68668e-18
c270 572:rbl0 544:preb  c=4.30453e-19
c269 572:rbl0 537:preb  c=3.99852e-20
c268 572:rbl0 396:rwl1  c=2.83669e-20
cg267 571:rbl0 0  c=1.56272e-16
c266 571:rbl0 543:preb  c=7.69982e-19
c265 571:rbl0 534:preb  c=2.00338e-20
c264 571:rbl0 388:rwl1  c=5.92449e-19
c263 571:rbl0 541:preb  c=9.36554e-19
c262 571:rbl0 533:preb  c=1.42337e-20
cg261 570:rbl0 0  c=3.88969e-16
c260 570:rbl0 536:preb  c=2.18396e-18
c259 570:rbl0 532:preb  c=2.1845e-18
c258 570:rbl0 515:preb  c=8.09022e-17
c257 570:rbl0 542:preb  c=6.06678e-17
c256 570:rbl0 544:preb  c=4.82875e-18
c255 570:rbl0 543:preb  c=2.26608e-18
c254 570:rbl0 537:preb  c=1.18394e-17
c253 570:rbl0 304:ln_xrs0|n_38  c=8.55649e-17
c252 570:rbl0 534:preb  c=9.56764e-18
c251 570:rbl0 538:preb  c=3.71149e-19
c250 570:rbl0 541:preb  c=1.36506e-19
c249 570:rbl0 530:preb  c=7.38899e-19
c248 570:rbl0 533:preb  c=1.60155e-20
c247 570:rbl0 525:preb  c=1.82026e-17
c246 570:rbl0 527:preb  c=8.43683e-18
cg245 569:rbl0 0  c=1.33662e-17
c244 569:rbl0 396:rwl1  c=1.07854e-18
c243 569:rbl0 397:rwl1  c=3.64021e-18
cg242 568:rbl0 0  c=2.75223e-17
c241 568:rbl0 397:rwl1  c=4.96053e-19
cg240 567:rbl0 0  c=4.25231e-16
c239 567:rbl0 397:rwl1  c=1.50542e-17
cg238 566:rbl0 0  c=4.07072e-18
c237 566:rbl0 396:rwl1  c=2.40197e-19
c236 566:rbl0 397:rwl1  c=1.29978e-18
cg235 xxrs0|xis1|mm1|gate 0  c=8.83804e-18
cg234 xxrs0|mmpre|drn 0  c=5.73253e-17
c233 xxrs0|mmpre|drn 304:ln_xrs0|n_38  c=1.35706e-16
cg232 xxarr|xi0|mra2|drn 0  c=7.81382e-18
cg231 xxarr|xi2|mra2|drn 0  c=9.48247e-18
cg230 xxrs0|xis1|mm0|gate 0  c=9.14552e-20
cg229 549:rbl0 0  c=1.3036e-17
c228 549:rbl0 515:preb  c=3.61654e-20
cg227 544:preb 0  c=1.16305e-17
c226 544:preb 304:ln_xrs0|n_38  c=5.60042e-18
cg225 543:preb 0  c=9.29603e-18
c224 543:preb 305:ln_xrs1|n_38  c=5.48659e-19
c223 543:preb 304:ln_xrs0|n_38  c=5.48659e-19
cg222 542:preb 0  c=3.67453e-16
c221 542:preb 304:ln_xrs0|n_38  c=1.26197e-17
c220 542:preb 305:ln_xrs1|n_38  c=1.26197e-17
cg219 541:preb 0  c=9.57066e-18
c218 541:preb 305:ln_xrs1|n_38  c=5.66343e-18
cg217 540:preb 0  c=5.01386e-17
cg216 539:preb 0  c=8.25367e-18
cg215 538:preb 0  c=2.22108e-18
cg214 537:preb 0  c=7.40668e-18
c213 537:preb 304:ln_xrs0|n_38  c=8.31737e-17
cg212 536:preb 0  c=8.25493e-18
cg211 535:preb 0  c=1.41961e-17
cg210 534:preb 0  c=2.53984e-18
c209 534:preb 304:ln_xrs0|n_38  c=1.0259e-18
c208 534:preb 305:ln_xrs1|n_38  c=1.0259e-18
cg207 533:preb 0  c=6.86044e-18
c206 533:preb 305:ln_xrs1|n_38  c=8.31803e-17
cg205 532:preb 0  c=1.41611e-17
cg204 530:preb 0  c=8.31946e-18
cg203 525:preb 0  c=1.97862e-17
c202 525:preb 304:ln_xrs0|n_38  c=2.18441e-18
c201 525:preb 305:ln_xrs1|n_38  c=1.82409e-18
cg200 521:preb 0  c=2.66512e-17
cg199 515:preb 0  c=3.87008e-17
cg198 510:we 0  c=4.02159e-16
c197 510:we xxdec|xi0|mm0|gate  c=3.14306e-18
c196 510:we 460:a  c=8.05884e-20
cg195 509:we 0  c=4.04445e-16
c194 509:we xxdec|xn1|mm1|gate  c=3.62034e-18
c193 509:we 462:a  c=1.40126e-17
cg192 508:we 0  c=2.04719e-18
c191 508:we 460:a  c=4.10319e-20
c190 508:we 482:re  c=1.03025e-17
c189 508:we 459:a  c=1.7252e-18
cg188 507:we 0  c=1.90948e-18
c187 507:we 462:a  c=1.3092e-18
c186 507:we 482:re  c=1.03025e-17
c185 507:we 459:a  c=1.7252e-18
cg184 506:we 0  c=3.17904e-16
c183 506:we 482:re  c=2.22482e-16
c182 506:we 486:re  c=5.69719e-19
c181 506:we 458:a  c=1.69387e-18
c180 506:we 459:a  c=2.70678e-17
c179 506:we 462:a  c=4.12463e-18
c178 506:we 460:a  c=9.03484e-17
c177 506:we 454:a  c=2.16334e-19
cg176 505:we 0  c=2.54875e-17
cg175 504:we 0  c=4.67194e-18
c174 504:we 460:a  c=5.10139e-20
c173 504:we 459:a  c=5.84283e-19
c172 504:we 482:re  c=1.7422e-18
cg171 503:we 0  c=2.53905e-17
c170 503:we 462:a  c=9.38187e-19
cg169 502:we 0  c=4.51347e-18
c168 502:we 462:a  c=4.61378e-18
c167 502:we 486:re  c=2.10501e-19
c166 502:we 459:a  c=5.84283e-19
c165 502:we 482:re  c=1.7422e-18
cg164 495:we 0  c=1.85061e-18
c163 495:we 459:a  c=2.83073e-18
c162 495:we 482:re  c=2.3351e-17
cg161 xxdec|xn0|mm2|gate 0  c=9.26963e-20
cg160 xxdec|xn0|mm0|gate 0  c=1.94832e-16
c159 xxdec|xn0|mm0|gate xxdec|xi0|mm0|gate  c=9.19971e-18
c158 xxdec|xn0|mm0|gate xxdec|xi0|mm1|gate  c=1.80865e-18
c157 xxdec|xn0|mm0|gate 460:a  c=3.31195e-18
cg156 xxdec|xn1|mm2|gate 0  c=9.26963e-20
c155 xxdec|xn1|mm2|gate xxdec|xn1|mm1|gate  c=1.14292e-17
cg154 xxdec|xn1|mm0|gate 0  c=2.09746e-16
c153 xxdec|xn1|mm0|gate xxdec|xn1|mm1|gate  c=5.4752e-17
c152 xxdec|xn1|mm0|gate 462:a  c=3.63251e-18
cg151 488:we 0  c=1.7398e-18
c150 488:we 462:a  c=1.07221e-18
c149 488:we 459:a  c=2.83073e-18
c148 488:we 482:re  c=2.3351e-17
cg147 487:we 0  c=5.43579e-17
c146 487:we 460:a  c=3.43802e-18
c145 487:we 435:a  c=4.31521e-18
c144 487:we 468:re  c=2.7987e-17
cg143 486:re 0  c=4.22243e-16
c142 486:re 462:a  c=1.90219e-18
cg141 485:re 0  c=4.20953e-16
c140 485:re xxdec|xn3|mm1|gate  c=3.62034e-18
c139 485:re 461:a  c=2.19911e-17
cg138 484:re 0  c=2.42975e-18
c137 484:re 462:a  c=7.39607e-20
c136 484:re 459:a  c=1.03025e-17
cg135 483:re 0  c=2.58702e-18
c134 483:re 461:a  c=1.43112e-18
c133 483:re 459:a  c=1.03025e-17
cg132 482:re 0  c=2.53928e-16
c131 482:re 457:a  c=1.89662e-17
c130 482:re 458:a  c=1.82944e-17
c129 482:re 459:a  c=5.44923e-16
c128 482:re 461:a  c=5.30328e-18
c127 482:re 462:a  c=9.37442e-17
c126 482:re 460:a  c=8.43864e-17
c125 482:re 456:a  c=6.36812e-18
c124 482:re 454:a  c=5.57621e-18
cg123 481:re 0  c=2.78301e-18
c122 481:re 462:a  c=3.39857e-20
c121 481:re 459:a  c=1.7422e-18
cg120 480:re 0  c=7.43779e-18
c119 480:re 462:a  c=8.22424e-19
cg118 479:re 0  c=7.69442e-18
c117 479:re 461:a  c=1.89562e-18
cg116 478:re 0  c=2.9774e-18
c115 478:re 461:a  c=5.04534e-18
c114 478:re 459:a  c=1.7422e-18
cg113 471:re 0  c=2.11252e-18
c112 471:re 462:a  c=5.08216e-19
c111 471:re 459:a  c=2.33798e-17
cg110 468:re 0  c=2.38636e-17
c109 468:re 460:a  c=3.56245e-18
c108 468:re 435:a  c=3.00415e-17
cg107 xxdec|xn2|mm2|gate 0  c=9.26963e-20
cg106 xxdec|xn2|mm0|gate 0  c=2.21633e-16
cg105 xxdec|xn3|mm2|gate 0  c=9.26963e-20
c104 xxdec|xn3|mm2|gate xxdec|xn3|mm1|gate  c=1.14292e-17
cg103 xxdec|xn3|mm0|gate 0  c=2.26957e-16
c102 xxdec|xn3|mm0|gate xxdec|xn3|mm1|gate  c=5.4752e-17
c101 xxdec|xn3|mm0|gate 461:a  c=3.63251e-18
cg100 463:re 0  c=2.2836e-18
c99 463:re 461:a  c=1.07221e-18
c98 463:re 459:a  c=2.38534e-17
cg97 462:a 0  c=4.24541e-16
cg96 461:a 0  c=4.2624e-16
cg95 460:a 0  c=4.34129e-16
cg94 459:a 0  c=1.46253e-16
cg93 458:a 0  c=4.93553e-19
cg92 457:a 0  c=1.40987e-18
cg91 455:a 0  c=3.22808e-18
cg90 453:a 0  c=8.75855e-18
cg89 452:a 0  c=4.98104e-18
cg88 451:a 0  c=2.26562e-18
cg87 450:a 0  c=8.78981e-18
cg86 442:a 0  c=6.26426e-18
cg85 438:a 0  c=2.71306e-18
cg84 435:a 0  c=3.36979e-17
cg83 xxdec|xi0|mm1|gate 0  c=1.20426e-19
cg82 xxdec|xi0|mm0|gate 0  c=2.81046e-16
cg81 xxdec|xn1|mm3|gate 0  c=1.30974e-17
cg80 xxdec|xn1|mm1|gate 0  c=2.18504e-16
cg79 xxdec|xn3|mm3|gate 0  c=1.30974e-17
cg78 xxdec|xn3|mm1|gate 0  c=2.22931e-16
cg77 428:a 0  c=6.62502e-18
cg76 427:rwl1 0  c=6.26934e-20
c75 427:rwl1 306:ln_xarr|x_r1c0|n_64  c=9.74023e-19
c74 427:rwl1 307:ln_xarr|x_r1c0|n_64  c=1.19879e-17
cg73 426:rwl1 0  c=1.31968e-18
c72 425:rwl1 313:ln_xarr|x_r1c1|n_64  c=9.43857e-19
c71 425:rwl1 314:ln_xarr|x_r1c1|n_64  c=1.1961e-17
cg70 424:rwl1 0  c=9.86409e-17
cg69 423:rwl1 0  c=5.93812e-16
cg68 422:rwl1 0  c=1.84518e-17
cg67 420:rwl1 0  c=1.74609e-18
cg66 418:rwl1 0  c=6.5742e-19
cg65 416:rwl1 0  c=3.6314e-17
cg64 415:rwl1 0  c=3.4047e-17
cg63 397:rwl1 0  c=1.5116e-16
cg62 396:rwl1 0  c=1.64725e-16
cg61 394:rwl1 0  c=3.34615e-18
cg60 392:rwl1 0  c=8.98632e-17
cg59 xxdec|xi4|mm1|drn 0  c=2.37034e-17
cg58 xxdec|xi4|mm0|drn 0  c=8.53772e-18
cg57 388:rwl1 0  c=3.25993e-18
c56 388:rwl1 307:ln_xarr|x_r1c0|n_64  c=2.07945e-18
cg55 387:rwl1 0  c=4.61304e-19
cg54 381:din0 0  c=4.05484e-16
cg53 380:din0 0  c=1.52544e-17
cg52 379:din0 0  c=2.00145e-17
cg51 378:din0 0  c=3.03438e-17
cg50 377:din0 0  c=1.6107e-17
cg49 376:din0 0  c=1.58249e-17
cg48 375:din0 0  c=3.31502e-16
cg47 xxwd0|xi0|mm1|gate 0  c=7.93151e-18
cg46 xxwd0|xi0|mm0|gate 0  c=6.67424e-19
cg45 369:din1 0  c=4.14906e-16
cg44 368:din1 0  c=1.53441e-17
cg43 367:din1 0  c=2.82144e-17
cg42 366:din1 0  c=2.05327e-17
cg41 365:din1 0  c=1.34687e-17
cg40 364:din1 0  c=3.23044e-16
cg39 363:din1 0  c=1.64468e-17
cg38 xxwd1|xi0|mm1|gate 0  c=3.55944e-18
cg37 xxwd1|xi0|mm0|gate 0  c=1.06761e-19
cg36 357:dout1 0  c=4.56105e-16
cg35 xxrs1|xis2|mm1|drn 0  c=5.77802e-17
cg34 xxrs1|xis2|mm0|drn 0  c=1.41902e-17
cg33 350:dout0 0  c=4.56345e-16
cg32 xxrs0|xis2|mm1|drn 0  c=5.69947e-17
cg31 xxrs0|xis2|mm0|drn 0  c=1.46857e-17
cg30 343:ln_xarr|x_r1c0|n_61 0  c=3.84172e-17
c29 343:ln_xarr|x_r1c0|n_61 301:ln_xarr|x_r1c0|n_62  c=2.328e-17
c28 343:ln_xarr|x_r1c0|n_61 299:ln_xarr|x_r1c0|n_62  c=1.54774e-17
c27 343:ln_xarr|x_r1c0|n_61 300:ln_xarr|x_r1c0|n_62  c=1.59518e-17
cg26 342:ln_xarr|x_r1c0|n_61 0  c=1.64913e-17
c25 342:ln_xarr|x_r1c0|n_61 299:ln_xarr|x_r1c0|n_62  c=2.13518e-17
cg24 341:ln_xarr|x_r1c0|n_61 0  c=4.08057e-17
c23 341:ln_xarr|x_r1c0|n_61 299:ln_xarr|x_r1c0|n_62  c=1.38757e-17
cg22 320:ln_xarr|x_r0c1|n_62 0  c=3.9142e-17
cg21 319:ln_xarr|x_r0c1|n_62 0  c=1.09767e-17
cg20 318:ln_xarr|x_r0c1|n_62 0  c=2.39208e-17
cg19 317:ln_xarr|x_r0c0|n_62 0  c=3.90908e-17
cg18 316:ln_xarr|x_r0c0|n_62 0  c=1.03993e-17
cg17 315:ln_xarr|x_r0c0|n_62 0  c=2.30066e-17
cg16 314:ln_xarr|x_r1c1|n_64 0  c=5.30092e-17
cg15 313:ln_xarr|x_r1c1|n_64 0  c=9.67307e-18
cg14 312:ln_xarr|x_r0c1|n_64 0  c=5.4215e-17
cg13 311:ln_xarr|x_r0c1|n_64 0  c=1.61739e-17
cg12 310:ln_xarr|x_r1c1|n_62 0  c=2.54545e-17
cg11 309:ln_xarr|x_r1c1|n_62 0  c=1.09703e-17
cg10 308:ln_xarr|x_r1c1|n_62 0  c=3.6811e-17
cg9 307:ln_xarr|x_r1c0|n_64 0  c=5.45848e-17
cg8 306:ln_xarr|x_r1c0|n_64 0  c=1.28857e-17
cg7 305:ln_xrs1|n_38 0  c=2.76197e-16
cg6 304:ln_xrs0|n_38 0  c=2.04694e-16
cg5 303:ln_xarr|x_r0c0|n_64 0  c=5.08369e-17
cg4 302:ln_xarr|x_r0c0|n_64 0  c=1.53052e-17
cg3 301:ln_xarr|x_r1c0|n_62 0  c=2.43865e-17
cg2 300:ln_xarr|x_r1c0|n_62 0  c=1.02855e-17
cg1 299:ln_xarr|x_r1c0|n_62 0  c=3.82694e-17
mxxwd1|xi1|mm0 xxwd1|xi1|mm0|drn xxwd1|xi1|mm0|gate gnd! xxwd1|xi1|mm0|bulk N w=0.36u
+  l=0.36u nf=1 m=1 ad=0.079p as=0.079p pd=1.16u ps=1.16u nrd=1.15789 nrs=1.15789
+  sa=0.22u sb=0.22u sd=0u
mxxwd1|xi0|mm0 xxwd1|xi0|mm0|drn xxwd1|xi0|mm0|gate gnd! xxwd1|xi0|mm0|bulk N w=0.36u
+  l=0.36u nf=1 m=1 ad=0.079p as=0.079p pd=1.16u ps=1.16u nrd=1.15789 nrs=1.15789
+  sa=0.22u sb=0.22u sd=0u
mxxwd0|xi1|mm0 xxwd0|xi1|mm0|drn xxwd0|xi1|mm0|gate gnd! xxwd0|xi1|mm0|bulk N w=0.36u
+  l=0.36u nf=1 m=1 ad=0.079p as=0.079p pd=1.16u ps=1.16u nrd=1.15789 nrs=1.15789
+  sa=0.22u sb=0.22u sd=0u
mxxwd0|xi0|mm0 xxwd0|xi0|mm0|drn xxwd0|xi0|mm0|gate gnd! xxwd0|xi0|mm0|bulk N w=0.36u
+  l=0.36u nf=1 m=1 ad=0.079p as=0.079p pd=1.16u ps=1.16u nrd=1.15789 nrs=1.15789
+  sa=0.22u sb=0.22u sd=0u
mxxrs1|xis2|mm0 xxrs1|xis2|mm0|drn xxrs1|xis2|mm0|gate gnd! xxrs1|xis2|mm0|bulk
+ N w=0.36u l=0.36u nf=1 m=1 ad=0.079p as=0.079p pd=1.16u ps=1.16u nrd=1.15789
+ nrs=1.15789 sa=0.22u sb=0.22u sd=0u
mxxrs1|xis1|mm0 xxrs1|xis1|mm0|drn xxrs1|xis1|mm0|gate gnd! xxrs1|xis1|mm0|bulk
+ N w=0.36u l=0.36u nf=1 m=1 ad=0.079p as=0.079p pd=1.16u ps=1.16u nrd=1.15789
+ nrs=1.15789 sa=0.22u sb=0.22u sd=0u
mxxrs0|xis2|mm0 xxrs0|xis2|mm0|drn xxrs0|xis2|mm0|gate gnd! xxrs0|xis2|mm0|bulk
+ N w=0.36u l=0.36u nf=1 m=1 ad=0.079p as=0.079p pd=1.16u ps=1.16u nrd=1.15789
+ nrs=1.15789 sa=0.22u sb=0.22u sd=0u
mxxrs0|xis1|mm0 xxrs0|xis1|mm0|drn xxrs0|xis1|mm0|gate gnd! xxrs0|xis1|mm0|bulk
+ N w=0.36u l=0.36u nf=1 m=1 ad=0.079p as=0.079p pd=1.16u ps=1.16u nrd=1.15789
+ nrs=1.15789 sa=0.22u sb=0.22u sd=0u
mxxdec|xn3|mm1 xxdec|xn3|mm1|drn xxdec|xn3|mm1|gate xxdec|xn3|mm1|src
+ xxdec|xn3|mm1|bulk N w=0.36u l=0.36u nf=1 m=1 ad=0.079p as=0.045p pd=1.16u ps=0.61u
+  nrd=1.15789 nrs=1.15789 sa=0.22u sb=0.22u sd=0u
mxxdec|xn3|mm0 xxdec|xn3|mm0|drn xxdec|xn3|mm0|gate gnd! xxdec|xn3|mm0|bulk N w=0.36u
+  l=0.36u nf=1 m=1 ad=0.045p as=0.079p pd=0.61u ps=1.16u nrd=1.15789 nrs=1.15789
+  sa=0.22u sb=0.22u sd=0u
mxxdec|xn2|mm1 xxdec|xn2|mm1|drn xxdec|xn2|mm1|gate xxdec|xn2|mm1|src
+ xxdec|xn2|mm1|bulk N w=0.36u l=0.36u nf=1 m=1 ad=0.079p as=0.045p pd=1.16u ps=0.61u
+  nrd=1.15789 nrs=1.15789 sa=0.22u sb=0.22u sd=0u
mxxdec|xn2|mm0 xxdec|xn2|mm0|drn xxdec|xn2|mm0|gate gnd! xxdec|xn2|mm0|bulk N w=0.36u
+  l=0.36u nf=1 m=1 ad=0.045p as=0.079p pd=0.61u ps=1.16u nrd=1.15789 nrs=1.15789
+  sa=0.22u sb=0.22u sd=0u
mxxdec|xn1|mm1 xxdec|xn1|mm1|drn xxdec|xn1|mm1|gate xxdec|xn1|mm1|src
+ xxdec|xn1|mm1|bulk N w=0.36u l=0.36u nf=1 m=1 ad=0.079p as=0.045p pd=1.16u ps=0.61u
+  nrd=1.15789 nrs=1.15789 sa=0.22u sb=0.22u sd=0u
mxxdec|xn1|mm0 xxdec|xn1|mm0|drn xxdec|xn1|mm0|gate gnd! xxdec|xn1|mm0|bulk N w=0.36u
+  l=0.36u nf=1 m=1 ad=0.045p as=0.079p pd=0.61u ps=1.16u nrd=1.15789 nrs=1.15789
+  sa=0.22u sb=0.22u sd=0u
mxxdec|xn0|mm1 xxdec|xn0|mm1|drn xxdec|xn0|mm1|gate xxdec|xn0|mm1|src
+ xxdec|xn0|mm1|bulk N w=0.36u l=0.36u nf=1 m=1 ad=0.079p as=0.045p pd=1.16u ps=0.61u
+  nrd=1.15789 nrs=1.15789 sa=0.22u sb=0.22u sd=0u
mxxdec|xn0|mm0 xxdec|xn0|mm0|drn xxdec|xn0|mm0|gate gnd! xxdec|xn0|mm0|bulk N w=0.36u
+  l=0.36u nf=1 m=1 ad=0.045p as=0.079p pd=0.61u ps=1.16u nrd=1.15789 nrs=1.15789
+  sa=0.22u sb=0.22u sd=0u
mxxdec|xi4|mm0 xxdec|xi4|mm0|drn xxdec|xi4|mm0|gate gnd! xxdec|xi4|mm0|bulk N w=0.36u
+  l=0.36u nf=1 m=1 ad=0.079p as=0.079p pd=1.16u ps=1.16u nrd=1.15789 nrs=1.15789
+  sa=0.22u sb=0.22u sd=0u
mxxdec|xi3|mm0 xxdec|xi3|mm0|drn xxdec|xi3|mm0|gate gnd! xxdec|xi3|mm0|bulk N w=0.36u
+  l=0.36u nf=1 m=1 ad=0.079p as=0.079p pd=1.16u ps=1.16u nrd=1.15789 nrs=1.15789
+  sa=0.22u sb=0.22u sd=0u
mxxdec|xi2|mm0 xxdec|xi2|mm0|drn xxdec|xi2|mm0|gate gnd! xxdec|xi2|mm0|bulk N w=0.36u
+  l=0.36u nf=1 m=1 ad=0.079p as=0.079p pd=1.16u ps=1.16u nrd=1.15789 nrs=1.15789
+  sa=0.22u sb=0.22u sd=0u
mxxdec|xi1|mm0 xxdec|xi1|mm0|drn xxdec|xi1|mm0|gate gnd! xxdec|xi1|mm0|bulk N w=0.36u
+  l=0.36u nf=1 m=1 ad=0.079p as=0.079p pd=1.16u ps=1.16u nrd=1.15789 nrs=1.15789
+  sa=0.22u sb=0.22u sd=0u
mxxdec|xi0|mm0 xxdec|xi0|mm0|drn xxdec|xi0|mm0|gate gnd! xxdec|xi0|mm0|bulk N w=0.36u
+  l=0.36u nf=1 m=1 ad=0.079p as=0.079p pd=1.16u ps=1.16u nrd=1.15789 nrs=1.15789
+  sa=0.22u sb=0.22u sd=0u
mxxarr|xi3|mra2 xxarr|xi3|mra2|drn xxarr|xi3|mra2|gate xxarr|xi3|mra2|src
+ xxarr|xi3|mra2|bulk N w=0.2u l=0.1u nf=1 m=1 ad=0.044p as=0.025p pd=0.84u ps=0.45u
+  nrd=1.15789 nrs=1.15789 sa=0.22u sb=0.22u sd=0u
mxxarr|xi3|mra1 xxarr|xi3|mra1|drn xxarr|xi3|mra1|gate gnd! xxarr|xi3|mra1|bulk
+ N w=0.2u l=0.1u nf=1 m=1 ad=0.025p as=0.044p pd=0.45u ps=0.84u nrd=1.15789
+ nrs=1.15789 sa=0.22u sb=0.22u sd=0u
mxxarr|xi3|mpg2 xxarr|xi3|mpg2|drn xxarr|xi3|mpg2|gate xxarr|xi3|mpg2|src
+ xxarr|xi3|mpg2|bulk N w=0.2u l=0.1u nf=1 m=1 ad=0.025p as=0.044p pd=0.45u ps=0.84u
+  nrd=1.15789 nrs=1.15789 sa=0.22u sb=0.22u sd=0u
mxxarr|xi3|mpg1 xxarr|xi3|mpg1|drn xxarr|xi3|mpg1|gate xxarr|xi3|mpg1|src
+ xxarr|xi3|mpg1|bulk N w=0.2u l=0.1u nf=1 m=1 ad=0.044p as=0.025p pd=0.84u ps=0.45u
+  nrd=1.15789 nrs=1.15789 sa=0.22u sb=0.22u sd=0u
mxxarr|xi3|mpd2 xxarr|xi3|mpd2|drn xxarr|xi3|mpd2|gate gnd! xxarr|xi3|mpd2|bulk
+ N w=0.2u l=0.1u nf=1 m=1 ad=0.025p as=0.025p pd=0.45u ps=0.45u nrd=1.15789
+ nrs=1.15789 sa=0.22u sb=0.22u sd=0u
mxxarr|xi3|mpd1 xxarr|xi3|mpd1|drn xxarr|xi3|mpd1|gate gnd! xxarr|xi3|mpd1|bulk
+ N w=0.2u l=0.1u nf=1 m=1 ad=0.025p as=0.025p pd=0.45u ps=0.45u nrd=1.15789
+ nrs=1.15789 sa=0.22u sb=0.22u sd=0u
mxxarr|xi2|mra2 xxarr|xi2|mra2|drn xxarr|xi2|mra2|gate xxarr|xi2|mra2|src
+ xxarr|xi2|mra2|bulk N w=0.2u l=0.1u nf=1 m=1 ad=0.044p as=0.025p pd=0.84u ps=0.45u
+  nrd=1.15789 nrs=1.15789 sa=0.22u sb=0.22u sd=0u
mxxarr|xi2|mra1 xxarr|xi2|mra1|drn xxarr|xi2|mra1|gate gnd! xxarr|xi2|mra1|bulk
+ N w=0.2u l=0.1u nf=1 m=1 ad=0.025p as=0.044p pd=0.45u ps=0.84u nrd=1.15789
+ nrs=1.15789 sa=0.22u sb=0.22u sd=0u
mxxarr|xi2|mpg2 xxarr|xi2|mpg2|drn xxarr|xi2|mpg2|gate xxarr|xi2|mpg2|src
+ xxarr|xi2|mpg2|bulk N w=0.2u l=0.1u nf=1 m=1 ad=0.025p as=0.044p pd=0.45u ps=0.84u
+  nrd=1.15789 nrs=1.15789 sa=0.22u sb=0.22u sd=0u
mxxarr|xi2|mpg1 xxarr|xi2|mpg1|drn xxarr|xi2|mpg1|gate xxarr|xi2|mpg1|src
+ xxarr|xi2|mpg1|bulk N w=0.2u l=0.1u nf=1 m=1 ad=0.044p as=0.025p pd=0.84u ps=0.45u
+  nrd=1.15789 nrs=1.15789 sa=0.22u sb=0.22u sd=0u
mxxarr|xi2|mpd2 xxarr|xi2|mpd2|drn xxarr|xi2|mpd2|gate gnd! xxarr|xi2|mpd2|bulk
+ N w=0.2u l=0.1u nf=1 m=1 ad=0.025p as=0.025p pd=0.45u ps=0.45u nrd=1.15789
+ nrs=1.15789 sa=0.22u sb=0.22u sd=0u
mxxarr|xi2|mpd1 xxarr|xi2|mpd1|drn xxarr|xi2|mpd1|gate gnd! xxarr|xi2|mpd1|bulk
+ N w=0.2u l=0.1u nf=1 m=1 ad=0.025p as=0.025p pd=0.45u ps=0.45u nrd=1.15789
+ nrs=1.15789 sa=0.22u sb=0.22u sd=0u
mxxarr|xi1|mra2 xxarr|xi1|mra2|drn xxarr|xi1|mra2|gate xxarr|xi1|mra2|src
+ xxarr|xi1|mra2|bulk N w=0.2u l=0.1u nf=1 m=1 ad=0.044p as=0.025p pd=0.84u ps=0.45u
+  nrd=1.15789 nrs=1.15789 sa=0.22u sb=0.22u sd=0u
mxxarr|xi1|mra1 xxarr|xi1|mra1|drn xxarr|xi1|mra1|gate gnd! xxarr|xi1|mra1|bulk
+ N w=0.2u l=0.1u nf=1 m=1 ad=0.025p as=0.044p pd=0.45u ps=0.84u nrd=1.15789
+ nrs=1.15789 sa=0.22u sb=0.22u sd=0u
mxxarr|xi1|mpg2 xxarr|xi1|mpg2|drn xxarr|xi1|mpg2|gate xxarr|xi1|mpg2|src
+ xxarr|xi1|mpg2|bulk N w=0.2u l=0.1u nf=1 m=1 ad=0.025p as=0.044p pd=0.45u ps=0.84u
+  nrd=1.15789 nrs=1.15789 sa=0.22u sb=0.22u sd=0u
mxxarr|xi1|mpg1 xxarr|xi1|mpg1|drn xxarr|xi1|mpg1|gate xxarr|xi1|mpg1|src
+ xxarr|xi1|mpg1|bulk N w=0.2u l=0.1u nf=1 m=1 ad=0.044p as=0.025p pd=0.84u ps=0.45u
+  nrd=1.15789 nrs=1.15789 sa=0.22u sb=0.22u sd=0u
mxxarr|xi1|mpd2 xxarr|xi1|mpd2|drn xxarr|xi1|mpd2|gate gnd! xxarr|xi1|mpd2|bulk
+ N w=0.2u l=0.1u nf=1 m=1 ad=0.025p as=0.025p pd=0.45u ps=0.45u nrd=1.15789
+ nrs=1.15789 sa=0.22u sb=0.22u sd=0u
mxxarr|xi1|mpd1 xxarr|xi1|mpd1|drn xxarr|xi1|mpd1|gate gnd! xxarr|xi1|mpd1|bulk
+ N w=0.2u l=0.1u nf=1 m=1 ad=0.025p as=0.025p pd=0.45u ps=0.45u nrd=1.15789
+ nrs=1.15789 sa=0.22u sb=0.22u sd=0u
mxxarr|xi0|mra2 xxarr|xi0|mra2|drn xxarr|xi0|mra2|gate xxarr|xi0|mra2|src
+ xxarr|xi0|mra2|bulk N w=0.2u l=0.1u nf=1 m=1 ad=0.044p as=0.025p pd=0.84u ps=0.45u
+  nrd=1.15789 nrs=1.15789 sa=0.22u sb=0.22u sd=0u
mxxarr|xi0|mra1 xxarr|xi0|mra1|drn xxarr|xi0|mra1|gate gnd! xxarr|xi0|mra1|bulk
+ N w=0.2u l=0.1u nf=1 m=1 ad=0.025p as=0.044p pd=0.45u ps=0.84u nrd=1.15789
+ nrs=1.15789 sa=0.22u sb=0.22u sd=0u
mxxarr|xi0|mpg2 xxarr|xi0|mpg2|drn xxarr|xi0|mpg2|gate xxarr|xi0|mpg2|src
+ xxarr|xi0|mpg2|bulk N w=0.2u l=0.1u nf=1 m=1 ad=0.025p as=0.044p pd=0.45u ps=0.84u
+  nrd=1.15789 nrs=1.15789 sa=0.22u sb=0.22u sd=0u
mxxarr|xi0|mpg1 xxarr|xi0|mpg1|drn xxarr|xi0|mpg1|gate xxarr|xi0|mpg1|src
+ xxarr|xi0|mpg1|bulk N w=0.2u l=0.1u nf=1 m=1 ad=0.044p as=0.025p pd=0.84u ps=0.45u
+  nrd=1.15789 nrs=1.15789 sa=0.22u sb=0.22u sd=0u
mxxarr|xi0|mpd2 xxarr|xi0|mpd2|drn xxarr|xi0|mpd2|gate gnd! xxarr|xi0|mpd2|bulk
+ N w=0.2u l=0.1u nf=1 m=1 ad=0.025p as=0.025p pd=0.45u ps=0.45u nrd=1.15789
+ nrs=1.15789 sa=0.22u sb=0.22u sd=0u
mxxarr|xi0|mpd1 xxarr|xi0|mpd1|drn xxarr|xi0|mpd1|gate gnd! xxarr|xi0|mpd1|bulk
+ N w=0.2u l=0.1u nf=1 m=1 ad=0.025p as=0.025p pd=0.45u ps=0.45u nrd=1.15789
+ nrs=1.15789 sa=0.22u sb=0.22u sd=0u
mxxwd1|xi1|mm1 xxwd1|xi1|mm1|drn xxwd1|xi1|mm1|gate vdd! xxwd1|xi1|mm1|bulk P w=1.035u
+  l=0.36u nf=1 m=1 ad=0.228p as=0.228p pd=2.51u ps=2.51u nrd=1.15789 nrs=1.15789
+  sa=0.22u sb=0.22u sd=0u
mxxwd1|xi0|mm1 xxwd1|xi0|mm1|drn xxwd1|xi0|mm1|gate vdd! xxwd1|xi0|mm1|bulk P w=1.035u
+  l=0.36u nf=1 m=1 ad=0.228p as=0.228p pd=2.51u ps=2.51u nrd=1.15789 nrs=1.15789
+  sa=0.22u sb=0.22u sd=0u
mxxwd0|xi1|mm1 xxwd0|xi1|mm1|drn xxwd0|xi1|mm1|gate vdd! xxwd0|xi1|mm1|bulk P w=1.035u
+  l=0.36u nf=1 m=1 ad=0.228p as=0.228p pd=2.51u ps=2.51u nrd=1.15789 nrs=1.15789
+  sa=0.22u sb=0.22u sd=0u
mxxwd0|xi0|mm1 xxwd0|xi0|mm1|drn xxwd0|xi0|mm1|gate vdd! xxwd0|xi0|mm1|bulk P w=1.035u
+  l=0.36u nf=1 m=1 ad=0.228p as=0.228p pd=2.51u ps=2.51u nrd=1.15789 nrs=1.15789
+  sa=0.22u sb=0.22u sd=0u
mxxrs1|xis2|mm1 xxrs1|xis2|mm1|drn xxrs1|xis2|mm1|gate vdd! xxrs1|xis2|mm1|bulk
+ P w=1.035u l=0.36u nf=1 m=1 ad=0.228p as=0.228p pd=2.51u ps=2.51u nrd=1.15789
+ nrs=1.15789 sa=0.22u sb=0.22u sd=0u
mxxrs1|xis1|mm1 xxrs1|xis1|mm1|drn xxrs1|xis1|mm1|gate vdd! xxrs1|xis1|mm1|bulk
+ P w=1.035u l=0.36u nf=1 m=1 ad=0.228p as=0.228p pd=2.51u ps=2.51u nrd=1.15789
+ nrs=1.15789 sa=0.22u sb=0.22u sd=0u
mxxrs1|mmpre xxrs1|mmpre|drn xxrs1|mmpre|gate vdd! xxrs1|mmpre|bulk P w=1.035u
+ l=0.36u nf=1 m=1 ad=0.228p as=0.228p pd=2.51u ps=2.51u nrd=1.15789 nrs=1.15789
+  sa=0.22u sb=0.22u sd=0u
mxxrs0|xis2|mm1 xxrs0|xis2|mm1|drn xxrs0|xis2|mm1|gate vdd! xxrs0|xis2|mm1|bulk
+ P w=1.035u l=0.36u nf=1 m=1 ad=0.228p as=0.228p pd=2.51u ps=2.51u nrd=1.15789
+ nrs=1.15789 sa=0.22u sb=0.22u sd=0u
mxxrs0|xis1|mm1 xxrs0|xis1|mm1|drn xxrs0|xis1|mm1|gate vdd! xxrs0|xis1|mm1|bulk
+ P w=1.035u l=0.36u nf=1 m=1 ad=0.228p as=0.228p pd=2.51u ps=2.51u nrd=1.15789
+ nrs=1.15789 sa=0.22u sb=0.22u sd=0u
mxxrs0|mmpre xxrs0|mmpre|drn xxrs0|mmpre|gate vdd! xxrs0|mmpre|bulk P w=1.035u
+ l=0.36u nf=1 m=1 ad=0.228p as=0.228p pd=2.51u ps=2.51u nrd=1.15789 nrs=1.15789
+  sa=0.22u sb=0.22u sd=0u
mxxdec|xn3|mm3 xxdec|xn3|mm3|drn xxdec|xn3|mm3|gate vdd! xxdec|xn3|mm3|bulk P w=1.035u
+  l=0.36u nf=1 m=1 ad=0.129p as=0.228p pd=1.285u ps=2.51u nrd=1.15789 nrs=1.15789
+  sa=0.22u sb=0.22u sd=0u
mxxdec|xn3|mm2 xxdec|xn3|mm2|drn xxdec|xn3|mm2|gate vdd! xxdec|xn3|mm2|bulk P w=1.035u
+  l=0.36u nf=1 m=1 ad=0.129p as=0.228p pd=1.285u ps=2.51u nrd=1.15789 nrs=1.15789
+  sa=0.22u sb=0.22u sd=0u
mxxdec|xn2|mm3 xxdec|xn2|mm3|drn xxdec|xn2|mm3|gate vdd! xxdec|xn2|mm3|bulk P w=1.035u
+  l=0.36u nf=1 m=1 ad=0.129p as=0.228p pd=1.285u ps=2.51u nrd=1.15789 nrs=1.15789
+  sa=0.22u sb=0.22u sd=0u
mxxdec|xn2|mm2 xxdec|xn2|mm2|drn xxdec|xn2|mm2|gate vdd! xxdec|xn2|mm2|bulk P w=1.035u
+  l=0.36u nf=1 m=1 ad=0.129p as=0.228p pd=1.285u ps=2.51u nrd=1.15789 nrs=1.15789
+  sa=0.22u sb=0.22u sd=0u
mxxdec|xn1|mm3 xxdec|xn1|mm3|drn xxdec|xn1|mm3|gate vdd! xxdec|xn1|mm3|bulk P w=1.035u
+  l=0.36u nf=1 m=1 ad=0.129p as=0.228p pd=1.285u ps=2.51u nrd=1.15789 nrs=1.15789
+  sa=0.22u sb=0.22u sd=0u
mxxdec|xn1|mm2 xxdec|xn1|mm2|drn xxdec|xn1|mm2|gate vdd! xxdec|xn1|mm2|bulk P w=1.035u
+  l=0.36u nf=1 m=1 ad=0.129p as=0.228p pd=1.285u ps=2.51u nrd=1.15789 nrs=1.15789
+  sa=0.22u sb=0.22u sd=0u
mxxdec|xn0|mm3 xxdec|xn0|mm3|drn xxdec|xn0|mm3|gate vdd! xxdec|xn0|mm3|bulk P w=1.035u
+  l=0.36u nf=1 m=1 ad=0.129p as=0.228p pd=1.285u ps=2.51u nrd=1.15789 nrs=1.15789
+  sa=0.22u sb=0.22u sd=0u
mxxdec|xn0|mm2 xxdec|xn0|mm2|drn xxdec|xn0|mm2|gate vdd! xxdec|xn0|mm2|bulk P w=1.035u
+  l=0.36u nf=1 m=1 ad=0.129p as=0.228p pd=1.285u ps=2.51u nrd=1.15789 nrs=1.15789
+  sa=0.22u sb=0.22u sd=0u
mxxdec|xi4|mm1 xxdec|xi4|mm1|drn xxdec|xi4|mm1|gate vdd! xxdec|xi4|mm1|bulk P w=1.035u
+  l=0.36u nf=1 m=1 ad=0.228p as=0.228p pd=2.51u ps=2.51u nrd=1.15789 nrs=1.15789
+  sa=0.22u sb=0.22u sd=0u
mxxdec|xi3|mm1 xxdec|xi3|mm1|drn xxdec|xi3|mm1|gate vdd! xxdec|xi3|mm1|bulk P w=1.035u
+  l=0.36u nf=1 m=1 ad=0.228p as=0.228p pd=2.51u ps=2.51u nrd=1.15789 nrs=1.15789
+  sa=0.22u sb=0.22u sd=0u
mxxdec|xi2|mm1 xxdec|xi2|mm1|drn xxdec|xi2|mm1|gate vdd! xxdec|xi2|mm1|bulk P w=1.035u
+  l=0.36u nf=1 m=1 ad=0.228p as=0.228p pd=2.51u ps=2.51u nrd=1.15789 nrs=1.15789
+  sa=0.22u sb=0.22u sd=0u
mxxdec|xi1|mm1 xxdec|xi1|mm1|drn xxdec|xi1|mm1|gate vdd! xxdec|xi1|mm1|bulk P w=1.035u
+  l=0.36u nf=1 m=1 ad=0.228p as=0.228p pd=2.51u ps=2.51u nrd=1.15789 nrs=1.15789
+  sa=0.22u sb=0.22u sd=0u
mxxdec|xi0|mm1 xxdec|xi0|mm1|drn xxdec|xi0|mm1|gate vdd! xxdec|xi0|mm1|bulk P w=1.035u
+  l=0.36u nf=1 m=1 ad=0.228p as=0.228p pd=2.51u ps=2.51u nrd=1.15789 nrs=1.15789
+  sa=0.22u sb=0.22u sd=0u
mxxarr|xi3|mpu2 xxarr|xi3|mpu2|drn xxarr|xi3|mpu2|gate vdd! xxarr|xi3|mpu2|bulk
+ P w=0.2u l=0.1u nf=1 m=1 ad=0.044p as=0.025p pd=0.84u ps=0.45u nrd=1.15789
+ nrs=1.15789 sa=0.22u sb=0.22u sd=0u
mxxarr|xi3|mpu1 xxarr|xi3|mpu1|drn xxarr|xi3|mpu1|gate vdd! xxarr|xi3|mpu1|bulk
+ P w=0.2u l=0.1u nf=1 m=1 ad=0.044p as=0.025p pd=0.84u ps=0.45u nrd=1.15789
+ nrs=1.15789 sa=0.22u sb=0.22u sd=0u
mxxarr|xi2|mpu2 xxarr|xi2|mpu2|drn xxarr|xi2|mpu2|gate vdd! xxarr|xi2|mpu2|bulk
+ P w=0.2u l=0.1u nf=1 m=1 ad=0.044p as=0.025p pd=0.84u ps=0.45u nrd=1.15789
+ nrs=1.15789 sa=0.22u sb=0.22u sd=0u
mxxarr|xi2|mpu1 xxarr|xi2|mpu1|drn xxarr|xi2|mpu1|gate vdd! xxarr|xi2|mpu1|bulk
+ P w=0.2u l=0.1u nf=1 m=1 ad=0.044p as=0.025p pd=0.84u ps=0.45u nrd=1.15789
+ nrs=1.15789 sa=0.22u sb=0.22u sd=0u
mxxarr|xi1|mpu2 xxarr|xi1|mpu2|drn xxarr|xi1|mpu2|gate vdd! xxarr|xi1|mpu2|bulk
+ P w=0.2u l=0.1u nf=1 m=1 ad=0.044p as=0.025p pd=0.84u ps=0.45u nrd=1.15789
+ nrs=1.15789 sa=0.22u sb=0.22u sd=0u
mxxarr|xi1|mpu1 xxarr|xi1|mpu1|drn xxarr|xi1|mpu1|gate vdd! xxarr|xi1|mpu1|bulk
+ P w=0.2u l=0.1u nf=1 m=1 ad=0.044p as=0.025p pd=0.84u ps=0.45u nrd=1.15789
+ nrs=1.15789 sa=0.22u sb=0.22u sd=0u
mxxarr|xi0|mpu2 xxarr|xi0|mpu2|drn xxarr|xi0|mpu2|gate vdd! xxarr|xi0|mpu2|bulk
+ P w=0.2u l=0.1u nf=1 m=1 ad=0.044p as=0.025p pd=0.84u ps=0.45u nrd=1.15789
+ nrs=1.15789 sa=0.22u sb=0.22u sd=0u
mxxarr|xi0|mpu1 xxarr|xi0|mpu1|drn xxarr|xi0|mpu1|gate vdd! xxarr|xi0|mpu1|bulk
+ P w=0.2u l=0.1u nf=1 m=1 ad=0.044p as=0.025p pd=0.84u ps=0.45u nrd=1.15789
+ nrs=1.15789 sa=0.22u sb=0.22u sd=0u
.ends ram8t_full

********************************************************************************
* Library          : ram8t_custom
* Cell             : ram8t_full_test
* View             : schematic
* View Search List : schematic hspice symbol
* View Stop List   : symbol
********************************************************************************
v0 vdd! gnd! dc=1.2
vdin1 din1 gnd! dc=0 pulse ( 1.2 0 0 100p 100p 9.9n 20n )
vdin0 din0 gnd! dc=0 pulse ( 0 1.2 0 100p 100p 9.9n 20n )
vpreb preb gnd! dc=0 pulse ( 0 1.2 5.5n 100p 100p 3n 10n )
vre re gnd! dc=0 pulse ( 0 1.2 6n 100p 100p 2n 10n )
vwe we gnd! dc=0 pulse ( 0 1.2 1n 100p 100p 2n 10n )
va a gnd! dc=0 pulse ( 0 1.2 10n 100p 100p 9.9n 20n )
xdut a din0 din1 dout0 dout1 preb re we ram8t_full
c1 dout1 gnd! c=10f
c0 dout0 gnd! c=10f

.tran 10p 20n start=0
.option opfile=1 split_dp=1
.option probe=1
.probe tran v(*) level=1
.probe tran v(a) v(din0) v(din1) v(dout0) v(dout1) v(preb) v(re) v(we)

.measure tran sample_1 find v(dout0) at=7.5n
.measure tran sample_2 find v(dout1) at=7.5n
.measure tran sample_3 find v(dout0) at=17.5n
.measure tran sample_4 find v(dout1) at=17.5n
.end

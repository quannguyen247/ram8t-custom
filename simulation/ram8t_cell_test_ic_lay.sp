* Initial state for ram8t_cell_test (post-layout, StarRC node names): Q=0, QB=VDD
.ic v(xi0.mpd2|gate)=0 v(xi0.mpd1|gate)=0.8
